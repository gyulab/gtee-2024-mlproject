// VerilogA for GB_lib, IWO_verliogA, veriloga

//*******************************************************************************
//* * School of Electrical and Computer Engineering, Georgia Institute of Technology
//* PI: Prof. Shimeng Yu
//* All rights reserved.
//*
//* Copyright of the model is maintained by the developers, and the model is distributed under
//* the terms of the Creative Commons Attribution-NonCommercial 4.0 International Public License
//* http://creativecommons.org/licenses/by-nc/4.0/legalcode.
//*
//* THIS SOFTWARE IS PROVIDED BY THE COPYRIGHT HOLDERS AND CONTRIBUTORS "AS IS" AND
//* ANY EXPRESS OR IMPLIED WARRANTIES, INCLUDING, BUT NOT LIMITED TO, THE IMPLIED
//* WARRANTIES OF MERCHANTABILITY AND FITNESS FOR A PARTICULAR PURPOSE ARE
//* DISCLAIMED. IN NO EVENT SHALL THE COPYRIGHT HOLDER OR CONTRIBUTORS BE LIABLE
//* FOR ANY DIRECT, INDIRECT, INCIDENTAL, SPECIAL, EXEMPLARY, OR CONSEQUENTIAL
//* DAMAGES (INCLUDING, BUT NOT LIMITED TO, PROCUREMENT OF SUBSTITUTE GOODS OR
//* SERVICES; LOSS OF USE, DATA, OR PROFITS; OR BUSINESS INTERRUPTION) HOWEVER
//* CAUSED AND ON ANY THEORY OF LIABILITY, WHETHER IN CONTRACT, STRICT LIABILITY,
//* OR TORT (INCLUDING NEGLIGENCE OR OTHERWISE) ARISING IN ANY WAY OUT OF THE USE
//* OF THIS SOFTWARE, EVEN IF ADVISED OF THE POSSIBILITY OF SUCH DAMAGE.
//*
//* Developer:
//*  Gihun Choe gchoe6@gatech.edu
//********************************************************************************/

`include "constants.vams"
`include "disciplines.vams"

module IWO_verliogA(d, g, s);
	inout d, g, s;
	electrical d, g, s;

	//***** parameters L and W ******//
	parameter real W = 2; //set on cadence
	parameter real L = 0.05; //set on cadence
	parameter real Temp = 25; //set on cadence as variable, e.g., temperature
	parameter real StressTime = 0; //set on cadence as variable, e.g., stresstime
	parameter MinVg = -1.0 ;
	parameter normVg = 0.2857142857142857 ;
	parameter MinVd = 0.01 ;
	parameter normVd = 0.4016064257028112 ;
	parameter MinLg = 0.05 ;
	parameter normLg = 20 ;
	parameter MinI = -24.83654843669889 ;
	parameter normI = 0.045949762018585485;
	parameter MinO = 8.15e-15 ;
	parameter normO =33613445378151.26;
	parameter Mintemp = 25.0;
	parameter normtemp = 0.016666666666666666;
	parameter Mints = 0;
	parameter normts = 0.001;

	real Vg, Vd, Vs, Vgs, Vds, Lg, Id, Cgg, Cgsd, Vgd;
	real Vgsraw, Vgdraw, dir;
	real ts, temp;
	// stress time, temperature
	// ts = 0 to 1000, temp = 25C or 85C

	real h1_0, h1_1, h1_2, h1_3, h1_4, h1_5, h1_6, h1_7, h1_8, h1_9, h1_10, h1_11, h1_12, h1_13, h1_14, h1_15, h1_16, h1_17, h1_18, h1_19, h1_20, h1_21, h1_22, h1_23, h1_24, h1_25, h1_26, h1_27, h1_28, h1_29, h1_30, h1_31, h1_32, h1_33, h1_34, h1_35, h1_36, h1_37, h1_38, h1_39, h1_40, h1_41, h1_42, h1_43, h1_44, h1_45, h1_46, h1_47, h1_48, h1_49;
	real h2_0, h2_1, h2_2, h2_3, h2_4, h2_5, h2_6, h2_7, h2_8, h2_9, h2_10, h2_11, h2_12, h2_13, h2_14, h2_15, h2_16, h2_17, h2_18, h2_19, h2_20, h2_21, h2_22, h2_23, h2_24, y;
	real hc1_0, hc1_1, hc1_2, hc1_3, hc1_4, hc1_5, hc1_6, hc1_7, hc1_8, hc1_9;
	real hc1_10, hc1_11, hc1_12, hc1_13, hc1_14, hc1_15, hc1_16;
	real hc2_0, hc2_1, hc2_2, hc2_3, hc2_4, hc2_5, hc2_6, hc2_7, hc2_8, hc2_9;
	real hc2_10, hc2_11, hc2_12, hc2_13, hc2_14, hc2_15, hc2_16, yc;

analog begin
	Vg = V(g) ;
	Vs = V(s) ;
	Vd = V(d) ;
	Vgsraw = Vg-Vs ;
	Vgdraw = Vg-Vd ;

if (Vgsraw >= Vgdraw) begin
	Vgs = ((Vg-Vs) - MinVg) * normVg ;
	dir = 1;
end

else begin
	Vgs = ((Vg-Vd) - MinVg) * normVg ;
	dir = -1;
end

	Vds = (abs(Vd-Vs) - MinVd) * normVd ;

	Lg = (L - MinLg)*normLg ;
	temp = (Temp - Mintemp)*normtemp ;
	ts = (StressTime - Mints)*normts ;

//******************** C-V NN **********************************//
hc1_0 = tanh(0.04915071*Vgs+-0.22193934*Vds+-0.7593927*Lg+-0.5542009);
hc1_1 = tanh(-0.5386426*Vgs+0.09759908*Vds+0.070394866*Lg+0.022503307);
hc1_2 = tanh(0.45929718*Vgs+0.6230113*Vds+0.14348903*Lg+-0.52340496);
hc1_3 = tanh(0.42468765*Vgs+0.12221526*Vds+0.10838072*Lg+0.47027177);
hc1_4 = tanh(-1.5640372*Vgs+0.13030031*Vds+0.47814217*Lg+0.55190086);
hc1_5 = tanh(1.4990448*Vgs+-0.5552569*Vds+-0.5868225*Lg+-0.31158358);
hc1_6 = tanh(1.4337695*Vgs+-0.7395633*Vds+-0.6467826*Lg+-0.48836154);
hc1_7 = tanh(0.99053556*Vgs+-0.56533486*Vds+0.14093444*Lg+-0.35388345);
hc1_8 = tanh(-1.0424674*Vgs+0.0065663788*Vds+0.3306938*Lg+0.49525642);
hc1_9 = tanh(0.743854*Vgs+-0.5813961*Vds+-0.19515125*Lg+-0.4935246);
hc1_10 = tanh(0.5294806*Vgs+-0.2591268*Vds+-0.13790491*Lg+-0.31317532);
hc1_11 = tanh(0.26149455*Vgs+-2.445509*Vds+-0.472639*Lg+0.08257839);
hc1_12 = tanh(-1.031864*Vgs+-0.052674334*Vds+0.6826103*Lg+0.56895113);
hc1_13 = tanh(0.50767463*Vgs+0.5269057*Vds+0.49826008*Lg+-0.566648);
hc1_14 = tanh(-1.7083333*Vgs+0.075654835*Vds+0.7909959*Lg+0.62746507);
hc1_15 = tanh(-0.27805543*Vgs+-0.3422888*Vds+0.23547372*Lg+-0.35782394);
hc1_16 = tanh(-1.1965085*Vgs+1.4846221*Vds+0.55899525*Lg+0.5260169);

hc2_0 = tanh(0.07733424*hc1_0+-0.2222065*hc1_1+0.026832305*hc1_2+0.11633152*hc1_3+0.17778008*hc1_4+0.024242321*hc1_5+-0.20472057*hc1_6+-0.071030974*hc1_7+0.10504634*hc1_8+0.3247371*hc1_9+0.43270278*hc1_10+-0.020716695*hc1_11+0.39938778*hc1_12+-0.12049217*hc1_13+-0.13757777*hc1_14+-0.18941562*hc1_15+-0.4268589*hc1_16+-0.12683037);
hc2_1 = tanh(0.19892192*hc1_0+-0.1360007*hc1_1+-0.20336024*hc1_2+0.0031327181*hc1_3+-0.09309421*hc1_4+-0.12868606*hc1_5+0.10332279*hc1_6+-0.26508978*hc1_7+0.32475725*hc1_8+0.45252386*hc1_9+0.44180426*hc1_10+0.15233837*hc1_11+0.005159585*hc1_12+-0.015594205*hc1_13+0.075489305*hc1_14+0.13857183*hc1_15+-0.43957594*hc1_16+0.12876678);
hc2_2 = tanh(0.19636881*hc1_0+2.184279*hc1_1+-0.3452746*hc1_2+-0.4772697*hc1_3+2.623504*hc1_4+-2.5059495*hc1_5+-2.5779731*hc1_6+-1.6763742*hc1_7+0.98623323*hc1_8+-0.8215465*hc1_9+-1.0898377*hc1_10+-0.79674786*hc1_11+0.48607305*hc1_12+-0.4703172*hc1_13+2.2915504*hc1_14+0.047422092*hc1_15+0.3094983*hc1_16+-0.030527668);
hc2_3 = tanh(0.23941448*hc1_0+-0.07160076*hc1_1+0.29133317*hc1_2+0.005076934*hc1_3+0.17233261*hc1_4+0.17521825*hc1_5+0.1669144*hc1_6+-0.13505243*hc1_7+0.14980432*hc1_8+0.055888224*hc1_9+-0.39520437*hc1_10+-0.013177027*hc1_11+0.062254302*hc1_12+-0.22766446*hc1_13+-0.09263883*hc1_14+-0.28706917*hc1_15+-0.055675194*hc1_16+-0.08250118);
hc2_4 = tanh(0.09186338*hc1_0+-0.01999815*hc1_1+0.33137882*hc1_2+-0.16183847*hc1_3+-0.57707304*hc1_4+0.48096886*hc1_5+0.071493834*hc1_6+-0.13407446*hc1_7+-0.16459137*hc1_8+0.023515375*hc1_9+0.46872413*hc1_10+0.13722663*hc1_11+0.30423188*hc1_12+0.083096646*hc1_13+-0.39699966*hc1_14+0.25838882*hc1_15+-0.45958596*hc1_16+0.23946233);
hc2_5 = tanh(-0.27142444*hc1_0+0.1914071*hc1_1+0.5060638*hc1_2+-0.13012071*hc1_3+-0.2037139*hc1_4+0.29814667*hc1_5+-0.3204845*hc1_6+0.118728325*hc1_7+0.14802305*hc1_8+-0.15718226*hc1_9+-0.024440827*hc1_10+0.27778938*hc1_11+-0.047202375*hc1_12+0.14307168*hc1_13+0.38233092*hc1_14+-0.38976455*hc1_15+-0.26603526*hc1_16+-0.10288494);
hc2_6 = tanh(-0.13307053*hc1_0+0.32495314*hc1_1+-0.044966113*hc1_2+0.18950532*hc1_3+0.58251965*hc1_4+-0.44257975*hc1_5+-0.918006*hc1_6+-0.18749726*hc1_7+0.46146265*hc1_8+-0.38253805*hc1_9+-0.5022407*hc1_10+0.058122106*hc1_11+0.8046936*hc1_12+-0.13810547*hc1_13+0.03592146*hc1_14+0.14762507*hc1_15+-0.29455996*hc1_16+0.07637344);
hc2_7 = tanh(-0.0052802535*hc1_0+0.55086625*hc1_1+-1.2698556*hc1_2+-0.20161049*hc1_3+2.002215*hc1_4+-0.67329276*hc1_5+-0.78839123*hc1_6+-0.82272124*hc1_7+1.4937757*hc1_8+-0.73722595*hc1_9+-0.6859407*hc1_10+0.3966282*hc1_11+1.6910958*hc1_12+-0.93085724*hc1_13+2.4953907*hc1_14+0.2220411*hc1_15+0.2569771*hc1_16+0.3517174);
hc2_8 = tanh(0.1986182*hc1_0+-0.025868667*hc1_1+0.36529526*hc1_2+-0.14498627*hc1_3+0.0885286*hc1_4+0.1687204*hc1_5+-0.14868014*hc1_6+-0.20689808*hc1_7+0.24722789*hc1_8+0.043144774*hc1_9+-0.14126699*hc1_10+-0.13808776*hc1_11+0.29469308*hc1_12+-0.27643335*hc1_13+-0.38473192*hc1_14+-0.22449632*hc1_15+-0.3195234*hc1_16+0.037153337);
hc2_9 = tanh(0.049271084*hc1_0+-0.09499244*hc1_1+0.42078283*hc1_2+0.092639685*hc1_3+-1.2726144*hc1_4+0.9162887*hc1_5+0.904721*hc1_6+1.1395215*hc1_7+-1.3767675*hc1_8+-0.0091874*hc1_9+0.31262678*hc1_10+-0.40726942*hc1_11+-1.3476667*hc1_12+-0.016200269*hc1_13+-1.3002973*hc1_14+0.36275*hc1_15+-0.61042273*hc1_16+0.006949956);
hc2_10 = tanh(0.09136664*hc1_0+-0.16255705*hc1_1+-0.32332692*hc1_2+0.32661682*hc1_3+-0.41495463*hc1_4+0.4401782*hc1_5+-0.12809044*hc1_6+-0.1553504*hc1_7+-0.37280977*hc1_8+0.2986172*hc1_9+0.22623424*hc1_10+0.31692135*hc1_11+0.11198977*hc1_12+0.38095957*hc1_13+-0.1578361*hc1_14+-0.17425038*hc1_15+-0.2219022*hc1_16+-0.07078295);
hc2_11 = tanh(0.33689055*hc1_0+0.39724785*hc1_1+-0.036893714*hc1_2+0.24480838*hc1_3+0.16414502*hc1_4+0.20773414*hc1_5+-0.038067672*hc1_6+0.43923053*hc1_7+-0.15963094*hc1_8+-0.2678527*hc1_9+0.3110377*hc1_10+-0.27888712*hc1_11+0.2631694*hc1_12+0.25851855*hc1_13+0.101733126*hc1_14+0.15101467*hc1_15+-0.2980497*hc1_16+0.23814851);
hc2_12 = tanh(-0.795547*hc1_0+0.44135538*hc1_1+0.2891938*hc1_2+0.7630201*hc1_3+2.0126994*hc1_4+-0.8034592*hc1_5+-2.7102323*hc1_6+-1.2325692*hc1_7+0.48748076*hc1_8+-1.9565684*hc1_9+-4.012801*hc1_10+-1.2804222*hc1_11+0.2380756*hc1_12+-0.39967382*hc1_13+1.4030623*hc1_14+-0.60662484*hc1_15+3.8633435*hc1_16+0.79516774);
hc2_13 = tanh(-0.11675434*hc1_0+0.016001716*hc1_1+-0.25946718*hc1_2+-0.015524454*hc1_3+-0.35919306*hc1_4+-0.44616887*hc1_5+0.49365565*hc1_6+-0.38328233*hc1_7+-0.2285652*hc1_8+0.13376299*hc1_9+-0.19156802*hc1_10+0.056028422*hc1_11+-0.09174214*hc1_12+-0.11826642*hc1_13+0.117404416*hc1_14+-0.1507949*hc1_15+0.19212815*hc1_16+-0.13624173);
hc2_14 = tanh(0.03936225*hc1_0+-0.4721447*hc1_1+-0.25327423*hc1_2+-0.34274346*hc1_3+-0.12512465*hc1_4+-0.24586023*hc1_5+-0.13143542*hc1_6+-0.4196574*hc1_7+0.1904185*hc1_8+0.1614839*hc1_9+-0.28033265*hc1_10+-0.34603179*hc1_11+0.27736706*hc1_12+0.08031542*hc1_13+-0.22302978*hc1_14+0.09607049*hc1_15+-0.23643805*hc1_16+0.2007879);
hc2_15 = tanh(-0.43412027*hc1_0+-0.32343552*hc1_1+0.23331167*hc1_2+0.2747345*hc1_3+-0.18353863*hc1_4+0.16592887*hc1_5+-0.38835827*hc1_6+-0.44111955*hc1_7+-0.0070112306*hc1_8+0.17457397*hc1_9+0.21936339*hc1_10+-0.07261076*hc1_11+0.17287144*hc1_12+-0.1820097*hc1_13+0.157127*hc1_14+-0.27049038*hc1_15+-0.2629586*hc1_16+0.25053084);
hc2_16 = tanh(-0.22721918*hc1_0+0.4838888*hc1_1+-0.049845178*hc1_2+0.20214*hc1_3+0.3696311*hc1_4+0.058600936*hc1_5+-0.17409873*hc1_6+-0.28529462*hc1_7+0.52774024*hc1_8+-0.045613773*hc1_9+-0.11005825*hc1_10+-0.24690871*hc1_11+0.4037387*hc1_12+-0.45051923*hc1_13+0.5304728*hc1_14+-0.012391669*hc1_15+-0.061173983*hc1_16+0.05388558);
yc = 0.09765993*hc2_0+0.14571704*hc2_1+-0.2519237*hc2_2+0.00070570107*hc2_3+-0.105962306*hc2_4+0.010266504*hc2_5+-0.1460968*hc2_6+-0.34957194*hc2_7+-0.0019327737*hc2_8+-0.4167839*hc2_9+-0.1645285*hc2_10+0.17705221*hc2_11+-0.11720503*hc2_12+-0.0016964282*hc2_13+-0.044352096*hc2_14+0.45301604*hc2_15+-0.21106915*hc2_16+0.24538882;

Cgg = (yc / normO + MinO)*W;
Cgsd = Cgg/2 ;

//******************** I-V NN **********************************//
h1_0 = tanh(1.1282667*Vgs+0.3794005*Vds+0.025397426*ts+-0.038533177*temp+-0.1677496);
h1_1 = tanh(-0.27192152*Vgs+-0.20871711*Vds+-0.0010777956*ts+-0.14553149*temp+-0.18988545);
h1_2 = tanh(-0.9569607*Vgs+0.28905407*Vds+0.025031902*ts+0.017075345*temp+0.1258303);
h1_3 = tanh(-0.7559323*Vgs+-0.4366921*Vds+-0.030702125*ts+-0.013537893*temp+0.31670582);
h1_4 = tanh(-0.9079872*Vgs+0.16359434*Vds+0.01501904*ts+-0.008168515*temp+0.22362977);
h1_5 = tanh(-1.9146564*Vgs+0.21035533*Vds+-0.013271433*ts+-0.009810618*temp+0.22583278);
h1_6 = tanh(0.74957734*Vgs+0.024969654*Vds+-0.0061878664*ts+0.012039838*temp+-0.26168606);
h1_7 = tanh(-0.9215082*Vgs+0.27680922*Vds+0.017355861*ts+0.006761439*temp+0.16155532);
h1_8 = tanh(0.7869249*Vgs+0.38940862*Vds+-0.02417194*ts+0.016023407*temp+-0.3102825);
h1_9 = tanh(-0.4096*Vgs+-0.2146307*Vds+-0.008528101*ts+-0.009078534*temp+0.2813039);
h1_10 = tanh(-0.99284637*Vgs+-0.35748893*Vds+-0.0040071434*ts+0.011493633*temp+0.22340664);
h1_11 = tanh(-0.24615571*Vgs+-0.60135007*Vds+0.032730915*ts+-0.029748606*temp+0.37181678);
h1_12 = tanh(-1.326009*Vgs+0.05318417*Vds+-0.0038358958*ts+-0.008770465*temp+0.2535748);
h1_13 = tanh(-1.7632582*Vgs+0.114986055*Vds+-0.007107649*ts+-0.008267409*temp+0.25371337);
h1_14 = tanh(-0.90630305*Vgs+0.107947536*Vds+0.0070669246*ts+0.0072797355*temp+0.08230163);
h1_15 = tanh(-0.59312564*Vgs+0.028175049*Vds+-0.020325884*ts+-0.0073090815*temp+0.22344646);
h1_16 = tanh(-0.71434474*Vgs+-0.38377059*Vds+-0.031507663*ts+-0.029990584*temp+0.30417585);
h1_17 = tanh(-1.0698096*Vgs+-0.2948349*Vds+-0.014420322*ts+0.023761837*temp+0.20603573);
h1_18 = tanh(0.8842626*Vgs+0.26937824*Vds+0.0063843555*ts+-0.002667012*temp+-0.30238762);
h1_19 = tanh(-1.3360697*Vgs+0.20875502*Vds+-0.0066004535*ts+0.0036795961*temp+0.19049276);
h1_20 = tanh(0.3591326*Vgs+0.4189844*Vds+-0.0040808413*ts+0.016342767*temp+-0.33453748);
h1_21 = tanh(0.88678366*Vgs+-0.16768588*Vds+-0.0052805385*ts+-0.009602238*temp+-0.075672);
h1_22 = tanh(-0.5207544*Vgs+-0.57649297*Vds+0.10682611*ts+0.009883717*temp+0.35188094);
h1_23 = tanh(-0.266409*Vgs+-0.51817507*Vds+-0.027876442*ts+0.07419719*temp+0.3059211);
h1_24 = tanh(-1.1736978*Vgs+-0.16602392*Vds+0.0044026244*ts+0.0038903963*temp+0.14568478);
h1_25 = tanh(1.0492297*Vgs+-0.1192573*Vds+-0.0061989063*ts+-0.007345379*temp+-0.19527903);
h1_26 = tanh(-1.468744*Vgs+0.22233386*Vds+-0.023752347*ts+0.007026477*temp+0.22226293);
h1_27 = tanh(-0.77353704*Vgs+0.2843634*Vds+0.022205332*ts+0.006195911*temp+0.102788664);
h1_28 = tanh(0.66337776*Vgs+0.37518746*Vds+0.0040446934*ts+0.01574477*temp+-0.23766038);
h1_29 = tanh(0.2900565*Vgs+0.31058198*Vds+0.044101506*ts+-0.02995037*temp+-0.35726333);
h1_30 = tanh(-0.24464178*Vgs+-0.561585*Vds+0.026993893*ts+-0.017557057*temp+0.31600678);
h1_31 = tanh(-1.060747*Vgs+0.18993062*Vds+0.003943524*ts+0.003083052*temp+0.13811496);
h1_32 = tanh(-1.2444118*Vgs+0.31042868*Vds+0.005755286*ts+-0.007962017*temp+0.23913127);
h1_33 = tanh(-0.9977182*Vgs+-0.17753616*Vds+-0.010325311*ts+-0.012409166*temp+0.20408043);
h1_34 = tanh(-0.9520359*Vgs+0.25570157*Vds+0.020054033*ts+-0.0019015362*temp+0.05491536);
h1_35 = tanh(-1.2446309*Vgs+-0.6118422*Vds+0.02726439*ts+0.0652638*temp+0.33367443);
h1_36 = tanh(-0.3348655*Vgs+-0.16725996*Vds+-0.051520575*ts+0.009831297*temp+0.22137539);
h1_37 = tanh(0.06754483*Vgs+0.5563889*Vds+0.018237459*ts+-0.004362874*temp+-0.222268);
h1_38 = tanh(1.3718047*Vgs+0.11161138*Vds+0.023596564*ts+0.026994469*temp+-0.31169078);
h1_39 = tanh(-1.4378034*Vgs+-0.24053107*Vds+-0.0023782442*ts+-0.0005836349*temp+0.20894799);

h2_0 = tanh(-1.1093996*h1_0+0.39071184*h1_1+-0.10875345*h1_2+1.3816398*h1_3+0.06209952*h1_4+0.22563401*h1_5+-0.25890815*h1_6+0.06922866*h1_7+-0.8748528*h1_8+0.0038726733*h1_9+1.5113298*h1_10+0.61216813*h1_11+0.29584152*h1_12+0.53088516*h1_13+0.33151892*h1_14+0.16796112*h1_15+1.3024746*h1_16+1.4439683*h1_17+-1.1136456*h1_18+0.33003297*h1_19+-0.30783382*h1_20+-0.09010424*h1_21+0.8552388*h1_22+0.75390965*h1_23+1.3854679*h1_24+-0.10634361*h1_25+0.19762856*h1_26+-0.04108123*h1_27+-1.2862558*h1_28+0.12105253*h1_29+0.73739445*h1_30+0.4073848*h1_31+0.18687324*h1_32+1.4408001*h1_33+0.009555815*h1_34+1.2486455*h1_35+0.04078127*h1_36+-0.59425896*h1_37+-0.59946316*h1_38+1.1032389*h1_39+-0.21257485);
h2_1 = tanh(0.8961181*h1_0+-0.45242047*h1_1+-1.1192117*h1_2+-0.19726604*h1_3+-0.57037336*h1_4+-2.5033336*h1_5+0.00037079517*h1_6+-1.1637759*h1_7+0.035458818*h1_8+0.90166694*h1_9+-0.4957216*h1_10+0.94091815*h1_11+-1.7582264*h1_12+-2.274817*h1_13+-3.932011*h1_14+0.43874595*h1_15+-0.009903214*h1_16+-0.66106015*h1_17+0.27148262*h1_18+-2.0277624*h1_19+-0.9781109*h1_20+2.8495896*h1_21+0.165856*h1_22+0.16775501*h1_23+-1.8945907*h1_24+1.4310331*h1_25+-2.0600684*h1_26+-1.7718335*h1_27+0.41877523*h1_28+-1.057885*h1_29+0.8937822*h1_30+-2.1125784*h1_31+-0.81953233*h1_32+-1.1408136*h1_33+-2.8206604*h1_34+-0.22416656*h1_35+0.070534915*h1_36+-0.8803306*h1_37+1.0338935*h1_38+-1.00777*h1_39+1.4582006);
h2_2 = tanh(-0.24672127*h1_0+-0.3206289*h1_1+-0.93802327*h1_2+0.03595895*h1_3+-0.57653004*h1_4+-1.4741266*h1_5+0.34360883*h1_6+-0.48083144*h1_7+-0.05411905*h1_8+-0.10346724*h1_9+-0.26217842*h1_10+0.015707841*h1_11+-0.89747167*h1_12+-1.2085974*h1_13+-1.7951887*h1_14+-0.2907552*h1_15+0.17613047*h1_16+-0.44106194*h1_17+0.046187762*h1_18+-1.4605397*h1_19+-0.54995346*h1_20+1.9742873*h1_21+0.3135925*h1_22+-0.052852467*h1_23+-0.4410456*h1_24+1.3879721*h1_25+-1.5223587*h1_26+-0.9938323*h1_27+-0.13759096*h1_28+-0.25320858*h1_29+0.056172624*h1_30+-1.2335962*h1_31+-0.56297535*h1_32+-0.46829337*h1_33+-1.6913061*h1_34+0.014762375*h1_35+-0.15116914*h1_36+-0.2582254*h1_37+0.5537032*h1_38+-0.36784476*h1_39+0.14797428);
h2_3 = tanh(-0.5263902*h1_0+0.06845398*h1_1+0.12922993*h1_2+0.61277825*h1_3+0.251391*h1_4+-0.0076849246*h1_5+-0.47424772*h1_6+-0.07105429*h1_7+-0.7496617*h1_8+0.30204856*h1_9+0.4250459*h1_10+0.6459755*h1_11+0.19806339*h1_12+0.20728907*h1_13+0.35896972*h1_14+0.16021167*h1_15+0.8653382*h1_16+0.34206057*h1_17+-0.56214714*h1_18+-0.07581569*h1_19+-0.59458643*h1_20+0.029474175*h1_21+0.841975*h1_22+0.6400379*h1_23+0.19568865*h1_24+-0.33103567*h1_25+0.023944365*h1_26+0.09731028*h1_27+-1.0383885*h1_28+-0.29597652*h1_29+0.29129967*h1_30+-0.13335054*h1_31+0.04681107*h1_32+0.6746209*h1_33+-0.10185025*h1_34+0.47607285*h1_35+0.52177197*h1_36+-0.15730137*h1_37+-0.38852653*h1_38+0.23474827*h1_39+0.12954423);
h2_4 = tanh(-0.043358445*h1_0+-0.14435132*h1_1+0.5716715*h1_2+-0.088082716*h1_3+0.8637104*h1_4+0.12999837*h1_5+-0.8903018*h1_6+0.7296442*h1_7+0.057410754*h1_8+0.7047462*h1_9+-0.21347524*h1_10+-0.29815266*h1_11+0.25441146*h1_12+0.31314832*h1_13+0.081854805*h1_14+0.5238319*h1_15+0.14491773*h1_16+-0.08677112*h1_17+-0.29004776*h1_18+0.53702587*h1_19+-0.101981334*h1_20+-0.25113863*h1_21+0.030126018*h1_22+-0.16069779*h1_23+0.24872252*h1_24+-0.83789015*h1_25+0.21400219*h1_26+0.33611986*h1_27+0.113908276*h1_28+-0.21663876*h1_29+-0.20433125*h1_30+0.5517392*h1_31+0.7600235*h1_32+0.09009161*h1_33+0.4715663*h1_34+-0.20599744*h1_35+0.5339855*h1_36+0.27759224*h1_37+-0.23047736*h1_38+0.12304229*h1_39+0.31584346);
h2_5 = tanh(2.02861*h1_0+-0.7515846*h1_1+0.2781536*h1_2+-0.8860039*h1_3+0.11111493*h1_4+-0.83985263*h1_5+0.038710557*h1_6+0.20854214*h1_7+0.44174665*h1_8+0.49299526*h1_9+-2.095153*h1_10+-0.43871415*h1_11+-0.83714473*h1_12+-0.8719183*h1_13+-0.8529497*h1_14+0.36109287*h1_15+-1.193578*h1_16+-1.8224934*h1_17+0.7944153*h1_18+-0.48845696*h1_19+-0.0027443324*h1_20+0.41184062*h1_21+-0.8041882*h1_22+-0.26382166*h1_23+-2.8294742*h1_24+0.43120334*h1_25+-0.48827127*h1_26+0.24503547*h1_27+1.3027307*h1_28+-0.6800571*h1_29+-0.3155447*h1_30+-0.41888514*h1_31+-0.029964235*h1_32+-1.9018338*h1_33+-0.029329209*h1_34+-1.7558268*h1_35+0.14781746*h1_36+0.20143288*h1_37+0.89780116*h1_38+-2.8170815*h1_39+0.94663507);
h2_6 = tanh(0.05134863*h1_0+0.10459184*h1_1+-0.6966869*h1_2+-0.20296444*h1_3+-0.92059606*h1_4+-0.20683527*h1_5+0.5300478*h1_6+-0.7453802*h1_7+0.15055317*h1_8+-0.6061432*h1_9+0.043451633*h1_10+0.37970653*h1_11+-0.38945445*h1_12+-0.06573638*h1_13+-0.2941287*h1_14+-0.4626145*h1_15+-0.11763532*h1_16+-0.044464234*h1_17+0.21181175*h1_18+-0.20395683*h1_19+0.10604853*h1_20+0.60137844*h1_21+-0.1887202*h1_22+0.16358912*h1_23+-0.1290996*h1_24+0.62944937*h1_25+-0.49634963*h1_26+-0.44877732*h1_27+-0.114180356*h1_28+0.16531871*h1_29+0.06446685*h1_30+-0.60566795*h1_31+-0.48083174*h1_32+-0.25102657*h1_33+-0.43777487*h1_34+-0.051346898*h1_35+-0.5434043*h1_36+-0.15028241*h1_37+0.35381955*h1_38+-0.071778744*h1_39+-0.31302324);
h2_7 = tanh(0.28372502*h1_0+-0.26429707*h1_1+-0.036741428*h1_2+-0.9281914*h1_3+0.027946655*h1_4+-0.23496532*h1_5+0.23338522*h1_6+-0.0034180346*h1_7+0.8940552*h1_8+-0.20247489*h1_9+-1.035792*h1_10+-0.788738*h1_11+-0.4391275*h1_12+-0.41295034*h1_13+-0.048419774*h1_14+-0.37054887*h1_15+-0.975697*h1_16+-0.92149794*h1_17+0.80214095*h1_18+-0.11674052*h1_19+0.80697495*h1_20+0.072992265*h1_21+-0.5535504*h1_22+-0.4503167*h1_23+-0.6855987*h1_24+0.271615*h1_25+-0.15527411*h1_26+0.20765945*h1_27+0.7922454*h1_28+-0.005335317*h1_29+-0.6955534*h1_30+-0.13895097*h1_31+-0.11939065*h1_32+-0.5006541*h1_33+0.20291921*h1_34+-0.9249179*h1_35+-0.18426822*h1_36+0.23122235*h1_37+0.36733732*h1_38+-0.36726928*h1_39+0.008230771);
h2_8 = tanh(0.43393508*h1_0+0.048963573*h1_1+-0.055494484*h1_2+-0.683663*h1_3+-0.36829352*h1_4+-0.0019568556*h1_5+0.14138581*h1_6+-0.11621891*h1_7+1.040016*h1_8+-0.7454697*h1_9+-0.18589315*h1_10+-0.4291594*h1_11+-0.31283167*h1_12+-0.0077382606*h1_13+0.03553993*h1_14+-0.43904445*h1_15+-0.6440814*h1_16+-0.51767653*h1_17+0.9276099*h1_18+-0.12874272*h1_19+0.94503754*h1_20+0.13086982*h1_21+-0.4319284*h1_22+-0.22811154*h1_23+-0.14144018*h1_24+-0.042522434*h1_25+-0.17611948*h1_26+0.09521266*h1_27+0.5803379*h1_28+0.23529804*h1_29+-0.49208915*h1_30+-0.0032189607*h1_31+0.113323726*h1_32+-0.217433*h1_33+0.033523273*h1_34+-0.66532797*h1_35+-0.22731158*h1_36+0.24522707*h1_37+0.076477714*h1_38+-0.12914301*h1_39+-0.09918303);
h2_9 = tanh(0.064244*h1_0+0.16560258*h1_1+-0.5919964*h1_2+-0.022297522*h1_3+-1.0280931*h1_4+-0.15374677*h1_5+0.7986226*h1_6+-0.5929562*h1_7+0.19159456*h1_8+-0.2527327*h1_9+-0.08871301*h1_10+0.32856235*h1_11+-0.15860455*h1_12+-0.051532917*h1_13+-0.33218148*h1_14+-0.8569913*h1_15+-0.120049395*h1_16+-0.12738557*h1_17+0.37914258*h1_18+-0.5226495*h1_19+-0.051033825*h1_20+0.2600818*h1_21+0.07039437*h1_22+-0.020037841*h1_23+0.0420295*h1_24+0.55133647*h1_25+-0.33112612*h1_26+-0.6417175*h1_27+0.26323655*h1_28+0.098470286*h1_29+-0.08158361*h1_30+-0.47061494*h1_31+-0.87245315*h1_32+-0.38097596*h1_33+-0.20761724*h1_34+0.18353808*h1_35+-0.54919904*h1_36+-0.41567487*h1_37+0.25586495*h1_38+-0.1206754*h1_39+-0.24468558);
h2_10 = tanh(-0.0053629796*h1_0+-0.14566189*h1_1+-0.015861405*h1_2+0.10286326*h1_3+-0.025211388*h1_4+0.17834209*h1_5+-0.22172527*h1_6+-0.10057878*h1_7+-0.2831103*h1_8+0.37136358*h1_9+-0.06628324*h1_10+0.6074676*h1_11+0.21676746*h1_12+-0.062194664*h1_13+0.032653034*h1_14+-0.025243338*h1_15+0.24695688*h1_16+0.13715461*h1_17+0.015973428*h1_18+-0.014985307*h1_19+-0.3651449*h1_20+0.22463118*h1_21+0.11774701*h1_22+0.2680345*h1_23+0.32297257*h1_24+-0.12074579*h1_25+-0.01033842*h1_26+0.06567707*h1_27+0.0775429*h1_28+-0.016729845*h1_29+0.33629295*h1_30+0.17007713*h1_31+-0.14136226*h1_32+-0.0012811992*h1_33+0.13294657*h1_34+0.03083783*h1_35+0.15064746*h1_36+-0.57021755*h1_37+0.053512517*h1_38+0.07450738*h1_39+0.32781157);
h2_11 = tanh(-1.1243526*h1_0+0.45198143*h1_1+-0.13416266*h1_2+1.2384216*h1_3+-0.07106313*h1_4+0.3442025*h1_5+-0.18504544*h1_6+-0.07105769*h1_7+-1.1378629*h1_8+0.013977069*h1_9+1.7707145*h1_10+0.26011774*h1_11+0.3613126*h1_12+0.70890754*h1_13+0.54430866*h1_14+-0.39988723*h1_15+0.9219399*h1_16+1.8993261*h1_17+-0.8925636*h1_18+0.5186107*h1_19+-0.2741215*h1_20+-0.13910957*h1_21+0.8153726*h1_22+0.36965698*h1_23+2.1590543*h1_24+-0.16741274*h1_25+0.4513358*h1_26+-0.112874076*h1_27+-1.4312949*h1_28+0.5763912*h1_29+0.51911694*h1_30+0.06417378*h1_31+0.12229689*h1_32+1.4519346*h1_33+0.04216094*h1_34+1.3277138*h1_35+-0.012603724*h1_36+-0.5562532*h1_37+-1.1771092*h1_38+1.4961605*h1_39+-0.5812139);
h2_12 = tanh(0.017610727*h1_0+0.15267809*h1_1+-0.39262006*h1_2+-0.36284325*h1_3+-0.915442*h1_4+-0.56882894*h1_5+0.7229526*h1_6+-0.70315826*h1_7+0.23394255*h1_8+-0.37501258*h1_9+-0.24827641*h1_10+0.18583557*h1_11+-0.7979365*h1_12+-0.41888958*h1_13+-0.73576087*h1_14+-0.31036833*h1_15+-0.31075045*h1_16+-0.20643143*h1_17+0.5054886*h1_18+-1.1632279*h1_19+0.11792078*h1_20+1.1179556*h1_21+-0.045268457*h1_22+0.36048618*h1_23+-0.24309707*h1_24+1.2939833*h1_25+-1.0678883*h1_26+-0.47590196*h1_27+0.3076787*h1_28+-0.22832383*h1_29+0.3219276*h1_30+-1.1763095*h1_31+-0.6650227*h1_32+-0.15582661*h1_33+-0.99876094*h1_34+-0.15491386*h1_35+-0.043313067*h1_36+-0.35955322*h1_37+0.671002*h1_38+-0.23777467*h1_39+-0.15320885);
h2_13 = tanh(-0.038032886*h1_0+0.03047834*h1_1+0.90233797*h1_2+-0.19286276*h1_3+0.44363293*h1_4+2.3148336*h1_5+-0.2318567*h1_6+0.31844395*h1_7+-0.13891809*h1_8+-0.12213461*h1_9+0.012021514*h1_10+-0.48383966*h1_11+1.2605984*h1_12+1.6612831*h1_13+2.4148226*h1_14+-0.092017636*h1_15+0.009226156*h1_16+0.5507857*h1_17+-0.25050852*h1_18+1.443946*h1_19+0.32755515*h1_20+-2.5056193*h1_21+-0.2841731*h1_22+0.02456853*h1_23+0.49816895*h1_24+-1.2408513*h1_25+1.7297186*h1_26+0.6958711*h1_27+-0.35796314*h1_28+0.64660937*h1_29+-0.3194765*h1_30+1.4631336*h1_31+0.45778188*h1_32+0.5869151*h1_33+1.6971577*h1_34+0.031174686*h1_35+0.16972616*h1_36+0.27554357*h1_37+-0.29718092*h1_38+0.7248531*h1_39+-0.57927257);
h2_14 = tanh(0.1841015*h1_0+-0.06488335*h1_1+0.04391033*h1_2+-0.12600937*h1_3+-0.26408595*h1_4+-0.06850337*h1_5+-0.0161547*h1_6+0.17799304*h1_7+-0.021258561*h1_8+-0.3344635*h1_9+-0.02650685*h1_10+-0.6517889*h1_11+0.13085972*h1_12+-0.05720117*h1_13+-0.15055265*h1_14+-0.13610028*h1_15+-0.11755812*h1_16+-0.056805253*h1_17+0.23635246*h1_18+0.018983677*h1_19+0.7128669*h1_20+0.019589813*h1_21+-0.4441481*h1_22+-0.34932542*h1_23+0.1783131*h1_24+-0.100375876*h1_25+0.009226679*h1_26+-0.20431656*h1_27+0.17787391*h1_28+0.22031869*h1_29+-0.49137577*h1_30+0.17240214*h1_31+-0.22781292*h1_32+0.09169097*h1_33+0.051654767*h1_34+-0.22534658*h1_35+-0.40675947*h1_36+0.10736405*h1_37+0.030468816*h1_38+0.018096117*h1_39+-0.29621652);
h2_15 = tanh(-0.15809894*h1_0+-0.0321883*h1_1+-0.8176682*h1_2+0.04473504*h1_3+-1.0853966*h1_4+-0.12504055*h1_5+0.39167565*h1_6+-0.97424084*h1_7+-0.11326799*h1_8+-0.5261513*h1_9+-0.02726119*h1_10+0.55676144*h1_11+-0.2687754*h1_12+-0.09549781*h1_13+-0.22559085*h1_14+-1.0267423*h1_15+0.4029071*h1_16+0.08015532*h1_17+-0.0667992*h1_18+-0.42293918*h1_19+-0.095072426*h1_20+0.5540836*h1_21+0.55101615*h1_22+0.49260858*h1_23+0.0278988*h1_24+0.41160056*h1_25+-0.37021804*h1_26+-1.5654372*h1_27+0.19345297*h1_28+0.43709973*h1_29+0.64632434*h1_30+-0.13795407*h1_31+-0.8479461*h1_32+0.006941091*h1_33+-0.6137376*h1_34+0.4196538*h1_35+-0.2819668*h1_36+-0.8642576*h1_37+-0.06365021*h1_38+0.24775615*h1_39+-0.8214586);
h2_16 = tanh(0.15700914*h1_0+-0.115349814*h1_1+-0.9580617*h1_2+-0.04386459*h1_3+-0.5570771*h1_4+-0.9489771*h1_5+0.74021816*h1_6+-0.7723447*h1_7+0.4168904*h1_8+-0.1333172*h1_9+-0.38565725*h1_10+0.44862172*h1_11+-0.75600183*h1_12+-0.74710095*h1_13+-0.7858853*h1_14+-0.18058634*h1_15+-0.26758295*h1_16+-0.095398135*h1_17+0.50052184*h1_18+-1.2454646*h1_19+0.30039418*h1_20+1.0401074*h1_21+0.25238222*h1_22+-0.02643598*h1_23+-0.28900632*h1_24+1.2944646*h1_25+-1.3091587*h1_26+-0.5214627*h1_27+0.15621774*h1_28+0.15992625*h1_29+0.3635733*h1_30+-1.1159519*h1_31+-0.85931283*h1_32+-0.36903423*h1_33+-0.8904804*h1_34+-0.12197183*h1_35+-0.13808067*h1_36+-0.4654338*h1_37+0.54622144*h1_38+-0.07380347*h1_39+-0.14383943);
h2_17 = tanh(-0.08558574*h1_0+-0.10251802*h1_1+-0.06198218*h1_2+-0.08211335*h1_3+0.23537774*h1_4+0.101260535*h1_5+-0.0024287659*h1_6+-0.28831393*h1_7+-0.099899024*h1_8+-0.51995414*h1_9+-0.19655037*h1_10+-0.24367024*h1_11+-0.037742425*h1_12+-0.19338453*h1_13+0.11405324*h1_14+-0.11601791*h1_15+0.02941468*h1_16+0.09897321*h1_17+-0.025058838*h1_18+-0.103842594*h1_19+0.49349663*h1_20+0.15659691*h1_21+-0.23477335*h1_22+-0.4530729*h1_23+0.078256585*h1_24+0.10606106*h1_25+-0.17510808*h1_26+0.2986495*h1_27+0.13068023*h1_28+0.3103466*h1_29+-0.57529527*h1_30+-0.111100465*h1_31+-0.097842865*h1_32+-0.20081802*h1_33+0.18275508*h1_34+-0.08575016*h1_35+-0.32623264*h1_36+0.61096495*h1_37+0.2190099*h1_38+-0.18064462*h1_39+-0.30186042);
h2_18 = tanh(-0.24755251*h1_0+0.05671287*h1_1+-0.6193193*h1_2+-0.070911705*h1_3+-0.72709197*h1_4+-0.079549484*h1_5+0.82486767*h1_6+-1.1305418*h1_7+0.23235522*h1_8+-0.4228661*h1_9+-0.025686637*h1_10+0.36143446*h1_11+-0.13405234*h1_12+-0.06485344*h1_13+-0.45268887*h1_14+-1.0138744*h1_15+-0.23192134*h1_16+-0.11907048*h1_17+0.019668197*h1_18+-0.32693097*h1_19+0.20068063*h1_20+0.23497537*h1_21+0.018363824*h1_22+0.22789717*h1_23+0.049883116*h1_24+0.3627671*h1_25+-0.4707087*h1_26+-0.8781474*h1_27+-0.085799895*h1_28+0.37681606*h1_29+0.40628496*h1_30+-0.40945765*h1_31+-0.70310444*h1_32+0.11603763*h1_33+-0.46205783*h1_34+-0.0028172769*h1_35+-0.46408615*h1_36+-0.42877617*h1_37+0.06276865*h1_38+0.048462305*h1_39+-0.3770752);
h2_19 = tanh(-0.3826095*h1_0+0.38634905*h1_1+0.8892909*h1_2+-0.005632573*h1_3+0.58979684*h1_4+2.677851*h1_5+-0.15519497*h1_6+0.23749702*h1_7+0.01178602*h1_8+-0.56236047*h1_9+0.34160444*h1_10+-0.2968895*h1_11+1.3464335*h1_12+2.0813417*h1_13+3.5475068*h1_14+-0.3492974*h1_15+-0.054887313*h1_16+0.5898538*h1_17+-0.4399056*h1_18+1.6013637*h1_19+0.58597034*h1_20+-2.7906635*h1_21+-0.40101063*h1_22+-0.45793822*h1_23+0.9408042*h1_24+-1.5017902*h1_25+1.6081113*h1_26+1.2997034*h1_27+-0.086313084*h1_28+0.6585853*h1_29+-0.73341274*h1_30+1.4000515*h1_31+0.21372432*h1_32+0.9891815*h1_33+1.9984581*h1_34+-0.22875527*h1_35+0.08651234*h1_36+0.24360155*h1_37+-0.9357435*h1_38+1.0153965*h1_39+-0.8399206);
y = -0.018895188*h2_0+0.02110091*h2_1+0.021382952*h2_2+-0.019025825*h2_3+-0.021814*h2_4+0.019384012*h2_5+0.021802353*h2_6+0.01914612*h2_7+0.01909566*h2_8+0.022502689*h2_9+-0.025614256*h2_10+-0.018844705*h2_11+0.021332342*h2_12+-0.021002335*h2_13+0.024344968*h2_14+0.022916285*h2_15+0.021138256*h2_16+0.02419743*h2_17+0.023355374*h2_18+-0.02106915*h2_19+0.5739352;
	Id = pow(10, (y/normI + MinI)) ;

if (Id <= 1e-15) begin //limit
	Id = 1e-15;
	//Id = Id;
end
else begin
	Id = Id;
end  //limit end

	I(g, d) <+ Cgsd*ddt(Vg-Vd) ;
	I(g, s) <+ Cgsd*ddt(Vg-Vs) ;

if (Vgsraw >= Vgdraw) begin
	I(d, s) <+ dir*Id*W ;

end

else begin
	I(d, s) <+ dir*Id*W ;

end

end

endmodule
