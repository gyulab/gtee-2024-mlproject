// VerilogA for GB_lib, IWO_verliogA, veriloga
//*******************************************************************************
//* * School of Electrical and Computer Engineering, Georgia Institute of Technology
//* PI: Prof. Shimeng Yu
//* All rights reserved.
//*
//* Copyright of the model is maintained by the developers, and the model is distributed under
//* the terms of the Creative Commons Attribution-NonCommercial 4.0 International Public License
//* http://creativecommons.org/licenses/by-nc/4.0/legalcode.
//*
//* THIS SOFTWARE IS PROVIDED BY THE COPYRIGHT HOLDERS AND CONTRIBUTORS "AS IS" AND
//* ANY EXPRESS OR IMPLIED WARRANTIES, INCLUDING, BUT NOT LIMITED TO, THE IMPLIED
//* WARRANTIES OF MERCHANTABILITY AND FITNESS FOR A PARTICULAR PURPOSE ARE
//* DISCLAIMED. IN NO EVENT SHALL THE COPYRIGHT HOLDER OR CONTRIBUTORS BE LIABLE
//* FOR ANY DIRECT, INDIRECT, INCIDENTAL, SPECIAL, EXEMPLARY, OR CONSEQUENTIAL
//* DAMAGES (INCLUDING, BUT NOT LIMITED TO, PROCUREMENT OF SUBSTITUTE GOODS OR
//* SERVICES; LOSS OF USE, DATA, OR PROFITS; OR BUSINESS INTERRUPTION) HOWEVER
//* CAUSED AND ON ANY THEORY OF LIABILITY, WHETHER IN CONTRACT, STRICT LIABILITY,
//* OR TORT (INCLUDING NEGLIGENCE OR OTHERWISE) ARISING IN ANY WAY OUT OF THE USE
//* OF THIS SOFTWARE, EVEN IF ADVISED OF THE POSSIBILITY OF SUCH DAMAGE.
//*
//* Developer:
//*  Gihun Choe gchoe6@gatech.edu
//********************************************************************************/

`include "constants.vams"
`include "disciplines.vams"

module IWO_verliogA(d, g, s);
        inout d, g, s;
        electrical d, g, s;

        //***** parameters L and W ******//
        parameter real W = 0.1; //get parameter fom spectre
        parameter real L = 0.05; //get parameter fom spectre
        parameter real T_stress = 0.0001; //set on cadence as variable
        parameter real T_rec = 0.001;     //set on cadence as variable
        parameter real Clk_loops = 50;    //set on cadence as variable
        parameter real V_ov = 1.7;        //set on cadence as variable
        parameter real Temp = 25;  //set on cadence as variable

        parameter MinVg = -1.0 ;
        parameter normVg = 0.2222222222222222 ;
        parameter MinVd = 0.01 ;
        parameter normVd = 0.2949852507374631 ;
        parameter MinLg = 0.05 ;
        parameter normLg = 1.4285714285714286 ;
        parameter MinO = 8.15e-15 ;
        parameter normO =33613445378151.26;
        parameter MinI = -23.98798356587402 ;
        parameter normI =0.04615548498417793;

        parameter Mint_stress = 0.0001 ;
        parameter normt_stress = 1111.111111111111 ;
        parameter Mint_rec = 0.0001 ;
        parameter normt_rec = 0.07629452739355005 ;
        parameter Minclk_loops = 100.0 ;
        parameter normclk_loops = 0.0011111111111111111 ;
        parameter Minv_ov = 1.0 ;
        parameter normv_ov = 1.4285714285714286 ;
        parameter Mintemperature = 25.0 ;
        parameter normtemperature = 0.016666666666666666 ;
        parameter Mindelta_Vth = 0.04321379542061602 ;
        parameter normdelta_Vth = 1.10036881607686 ;

        real hvth1_0, hvth1_1, hvth1_2, hvth1_3, hvth1_4, hvth1_5, hvth1_6, hvth1_7, hvth1_8, hvth1_9, hvth1_10, hvth1_11, hvth1_12, hvth1_13, hvth1_14, hvth1_15, hvth1_16, hvth1_17, hvth1_18, hvth1_19;
        real hvth2_0, hvth2_1, hvth2_2, hvth2_3, hvth2_4, hvth2_5, hvth2_6, hvth2_7, hvth2_8, hvth2_9;

        real Vg, Vd, Vs, Vgs, Vds, Lg, Id, Cgg, Cgsd, Vgd;
        real Vgsraw, Vgdraw, dir;
        real t_stress, v_ov, t_rec, clk_loops, temp, delta_Vth;

        real h1_0, h1_1, h1_2, h1_3, h1_4, h1_5, h1_6, h1_7, h1_8, h1_9, h1_10, h1_11, h1_12, h1_13, h1_14, h1_15, h1_16, h1_17, h1_18, h1_19, h1_20, h1_21, h1_22, h1_23, h1_24;
        real h2_0, h2_1, h2_2, h2_3, h2_4, h2_5, h2_6, h2_7, h2_8, h2_9, h2_10, h2_11, h2_12, h2_13, h2_14, h2_15, h2_16, y;
        real hc1_0, hc1_1, hc1_2, hc1_3, hc1_4, hc1_5, hc1_6, hc1_7, hc1_8, hc1_9;
        real hc1_10, hc1_11, hc1_12, hc1_13, hc1_14, hc1_15, hc1_16;
        real hc2_0, hc2_1, hc2_2, hc2_3, hc2_4, hc2_5, hc2_6, hc2_7, hc2_8, hc2_9;
        real hc2_10, hc2_11, hc2_12, hc2_13, hc2_14, hc2_15, hc2_16, yc, yvth;

analog begin

t_stress = (T_stress - Mint_stress)*normt_stress;
v_ov = (V_ov - Minv_ov)*normv_ov;
t_rec = (T_rec - Mint_rec)*normt_rec ;
clk_loops = (Clk_loops - Minclk_loops)*normclk_loops ;
temp = (Temp - Mintemperature)*normtemperature ;

//******************** delta_Vth NN **********************************//

hvth1_0 = tanh(-0.23620945*t_stress+-0.11422197*t_rec+-0.47228724*clk_loops+-0.14914739*v_ov+0.060948677*temp+-0.041763097);
hvth1_1 = tanh(0.028779808*t_stress+-0.3255204*t_rec+-0.35955793*clk_loops+0.07913537*v_ov+-0.35168025*temp+0.009527014);
hvth1_2 = tanh(-0.23698017*t_stress+-0.031253465*t_rec+0.4063394*clk_loops+0.11984312*v_ov+0.4131939*temp+0.13395193);
hvth1_3 = tanh(-0.50531137*t_stress+0.46174458*t_rec+-0.1782618*clk_loops+0.17201678*v_ov+0.32447937*temp+-0.07247048);
hvth1_4 = tanh(0.4709104*t_stress+0.024262382*t_rec+-0.5249183*clk_loops+0.21752039*v_ov+-0.29306147*temp+0.014862842);
hvth1_5 = tanh(-0.02446169*t_stress+0.3921463*t_rec+-0.10286931*clk_loops+-0.22758731*v_ov+-0.31253672*temp+0.025595723);
hvth1_6 = tanh(-0.268575*t_stress+-0.18649903*t_rec+0.07081949*clk_loops+-0.3853843*v_ov+-0.13099946*temp+0.05944069);
hvth1_7 = tanh(0.5114621*t_stress+-0.06406127*t_rec+0.15252858*clk_loops+-0.17643532*v_ov+0.1051611*temp+0.0014484077);
hvth1_8 = tanh(0.4923979*t_stress+-0.26999214*t_rec+0.3184994*clk_loops+0.11739618*v_ov+-0.43133062*temp+-0.028646497);
hvth1_9 = tanh(0.055534013*t_stress+-0.43234816*t_rec+-0.39688012*clk_loops+-0.48029068*v_ov+0.27702916*temp+0.106240295);
hvth1_10 = tanh(-0.17787331*t_stress+0.075013824*t_rec+-0.25544536*clk_loops+-0.038302206*v_ov+0.58043146*temp+0.09505023);
hvth1_11 = tanh(0.33054048*t_stress+-0.26726386*t_rec+0.14767885*clk_loops+0.2039868*v_ov+0.25976893*temp+0.0515087);
hvth1_12 = tanh(-0.49343204*t_stress+-0.38504344*t_rec+-0.043122437*clk_loops+0.41836444*v_ov+-0.09325249*temp+0.0034997498);
hvth1_13 = tanh(0.18222524*t_stress+0.6223577*t_rec+-0.022172648*clk_loops+0.08148197*v_ov+-0.032767747*temp+0.074112795);
hvth1_14 = tanh(-0.2362092*t_stress+-0.039774742*t_rec+0.26439178*clk_loops+-0.4139979*v_ov+0.18316038*temp+-0.3532865);
hvth1_15 = tanh(-0.3070481*t_stress+-0.11789334*t_rec+-0.34454498*clk_loops+-0.13262805*v_ov+0.16419725*temp+-0.16610207);
hvth1_16 = tanh(-0.3235092*t_stress+-0.030802485*t_rec+-0.14576414*clk_loops+0.28888705*v_ov+-0.2752622*temp+0.016559413);
hvth1_17 = tanh(0.39718556*t_stress+0.17403921*t_rec+0.3695224*clk_loops+0.082769506*v_ov+0.37886643*temp+0.06958915);
hvth1_18 = tanh(-0.049671166*t_stress+-0.1643029*t_rec+0.04437352*clk_loops+-0.0018665142*v_ov+-0.27600884*temp+-0.0013660155);
hvth1_19 = tanh(-0.2352259*t_stress+-0.10144812*t_rec+0.5238022*clk_loops+0.15918866*v_ov+-0.3490547*temp+0.094069764);

hvth2_0 = tanh(-0.16845305*hvth1_0+0.39756483*hvth1_1+0.16693518*hvth1_2+0.30869013*hvth1_3+-0.18108903*hvth1_4+-0.22460845*hvth1_5+-0.0035969557*hvth1_6+0.13595408*hvth1_7+0.24270168*hvth1_8+0.10163385*hvth1_9+0.18189007*hvth1_10+0.3038997*hvth1_11+-0.07428631*hvth1_12+0.42502534*hvth1_13+-0.14626172*hvth1_14+0.15082976*hvth1_15+-0.023482028*hvth1_16+-0.23518007*hvth1_17+-0.26763427*hvth1_18+0.27538553*hvth1_19+-0.03784745);
hvth2_1 = tanh(-0.41794166*hvth1_0+0.37053975*hvth1_1+-0.26791015*hvth1_2+-0.11355441*hvth1_3+-0.5075522*hvth1_4+0.3045135*hvth1_5+0.34555352*hvth1_6+0.14713447*hvth1_7+0.43753296*hvth1_8+-0.38279983*hvth1_9+-0.046737093*hvth1_10+0.4014616*hvth1_11+-0.020086141*hvth1_12+0.24303234*hvth1_13+-0.33418557*hvth1_14+-0.5091438*hvth1_15+0.18578485*hvth1_16+-0.1603029*hvth1_17+-0.08585446*hvth1_18+0.5277006*hvth1_19+0.070012085);
hvth2_2 = tanh(-0.14573708*hvth1_0+0.3184643*hvth1_1+0.2748625*hvth1_2+-0.23226483*hvth1_3+0.35325083*hvth1_4+0.1482115*hvth1_5+0.054981463*hvth1_6+0.07355818*hvth1_7+-0.36879742*hvth1_8+0.2377312*hvth1_9+0.25506988*hvth1_10+0.33719558*hvth1_11+0.4197101*hvth1_12+0.14284953*hvth1_13+-0.022160064*hvth1_14+0.06548938*hvth1_15+0.31598723*hvth1_16+0.26018983*hvth1_17+0.22775526*hvth1_18+0.16941279*hvth1_19+0.039906014);
hvth2_3 = tanh(0.03997243*hvth1_0+-0.1039401*hvth1_1+0.07319529*hvth1_2+-0.4143416*hvth1_3+0.16619112*hvth1_4+0.40054905*hvth1_5+0.0026044135*hvth1_6+-0.37246403*hvth1_7+-0.12070038*hvth1_8+0.3703949*hvth1_9+-0.25257835*hvth1_10+0.41636255*hvth1_11+0.3992935*hvth1_12+-0.3524762*hvth1_13+-0.18442999*hvth1_14+-0.10957257*hvth1_15+0.35311857*hvth1_16+0.3581483*hvth1_17+0.13963126*hvth1_18+-0.18214768*hvth1_19+0.033594046);
hvth2_4 = tanh(-0.06959928*hvth1_0+-0.16917941*hvth1_1+-0.21075183*hvth1_2+0.28207237*hvth1_3+0.15581249*hvth1_4+-0.30225942*hvth1_5+0.28091654*hvth1_6+-0.4213002*hvth1_7+-0.4188872*hvth1_8+-0.18873656*hvth1_9+-0.05960784*hvth1_10+-0.19246225*hvth1_11+-0.09820488*hvth1_12+-0.03853728*hvth1_13+-0.0039159185*hvth1_14+0.035747003*hvth1_15+0.3010332*hvth1_16+0.1148045*hvth1_17+-0.3731184*hvth1_18+0.37786087*hvth1_19+0.0018480162);
hvth2_5 = tanh(0.3516192*hvth1_0+-0.3393518*hvth1_1+-0.2819159*hvth1_2+-0.40437645*hvth1_3+-0.41484287*hvth1_4+0.2371237*hvth1_5+0.19181025*hvth1_6+0.37355548*hvth1_7+-0.1776793*hvth1_8+0.39244145*hvth1_9+0.1692209*hvth1_10+0.42198882*hvth1_11+0.4604563*hvth1_12+0.3640072*hvth1_13+0.39516565*hvth1_14+-0.27230933*hvth1_15+-0.33197865*hvth1_16+0.34897798*hvth1_17+-0.12794481*hvth1_18+0.45925367*hvth1_19+0.039266337);
hvth2_6 = tanh(0.18713506*hvth1_0+-0.13902345*hvth1_1+-0.29257163*hvth1_2+-0.0020112314*hvth1_3+-0.3171185*hvth1_4+0.2552745*hvth1_5+0.32808417*hvth1_6+0.23648283*hvth1_7+0.16705322*hvth1_8+0.113825805*hvth1_9+-0.23494478*hvth1_10+-0.14338814*hvth1_11+0.28235865*hvth1_12+-0.22754785*hvth1_13+0.4243886*hvth1_14+-0.3482737*hvth1_15+0.4114932*hvth1_16+0.09327023*hvth1_17+0.31020725*hvth1_18+-0.16473684*hvth1_19+-0.053053144);
hvth2_7 = tanh(0.37427378*hvth1_0+-0.16942349*hvth1_1+-0.31311038*hvth1_2+-0.3445607*hvth1_3+0.18884918*hvth1_4+0.23512177*hvth1_5+-0.43438914*hvth1_6+-0.28158382*hvth1_7+-0.17749362*hvth1_8+0.2672613*hvth1_9+0.4329218*hvth1_10+-0.14370936*hvth1_11+-0.22237973*hvth1_12+-0.15948312*hvth1_13+-0.37799123*hvth1_14+0.0115602*hvth1_15+-0.35784122*hvth1_16+0.48435572*hvth1_17+-0.41795096*hvth1_18+0.34065259*hvth1_19+0.031116992);
hvth2_8 = tanh(0.16162485*hvth1_0+0.20162259*hvth1_1+0.13203059*hvth1_2+-0.521588*hvth1_3+0.414747*hvth1_4+-0.10304635*hvth1_5+-0.20306803*hvth1_6+0.5009071*hvth1_7+0.07902086*hvth1_8+0.2757893*hvth1_9+-0.06971512*hvth1_10+-0.20647134*hvth1_11+-0.4602277*hvth1_12+-0.03632996*hvth1_13+-0.44813243*hvth1_14+-0.21619838*hvth1_15+0.28076693*hvth1_16+0.12535621*hvth1_17+0.43065372*hvth1_18+0.06388416*hvth1_19+0.031914692);
hvth2_9 = tanh(-0.41457635*hvth1_0+-0.09908786*hvth1_1+-0.2014291*hvth1_2+0.4129428*hvth1_3+-0.15876462*hvth1_4+-0.1535896*hvth1_5+0.37809083*hvth1_6+0.41081986*hvth1_7+0.11348377*hvth1_8+-0.11943263*hvth1_9+0.0014336263*hvth1_10+-0.12349735*hvth1_11+-0.3121594*hvth1_12+0.14242256*hvth1_13+0.009055796*hvth1_14+0.11027221*hvth1_15+-0.41051406*hvth1_16+-0.33950076*hvth1_17+-0.44527945*hvth1_18+0.019572979*hvth1_19+0.038242202);

yvth = -0.29885656*hvth2_0+0.22027107*hvth2_1+0.42393205*hvth2_2+0.51505446*hvth2_3+0.33099476*hvth2_4+0.26275173*hvth2_5+-0.26267987*hvth2_6+0.046849344*hvth2_7+-0.40909058*hvth2_8+0.35796097*hvth2_9+0.04243591;

delta_Vth = (yvth - Mindelta_Vth) * normdelta_Vth;
$strobe("dvth=$g",delta_Vth);

        Vg = V(g) ;
        Vs = V(s) ;
        Vd = V(d) ;
        Vgsraw = Vg-Vs ;
        Vgdraw = Vg-Vd ;

if (Vgsraw >= Vgdraw) begin
        Vgs = ((Vg-Vs) - MinVg) * normVg ;
        dir = 1;
end

else begin
        Vgs = ((Vg-Vd) - MinVg) * normVg ;
        dir = -1;
end

        Vds = (abs(Vd-Vs) - MinVd) * normVd ;
        Vgs = Vgs - delta_Vth ; // BTI Vth variation
        Lg = (L -MinLg)*normLg ;

//******************** C-V NN **********************************//
hc1_0 = tanh(-0.99871427*Vgs+-0.16952373*Vds+0.32118186*Lg+0.41485423);
hc1_1 = tanh(0.31587568*Vgs+0.13397887*Vds+-0.4541538*Lg+-0.3630942);
hc1_2 = tanh(-0.76281804*Vgs+0.09352969*Vds+1.1961353*Lg+0.3904977);
hc1_3 = tanh(-1.115087*Vgs+0.85752946*Vds+-0.11746484*Lg+0.5500279);
hc1_4 = tanh(1.0741386*Vgs+0.82041687*Vds+0.19092631*Lg+-0.4009425);
hc1_5 = tanh(-0.47921795*Vgs+-0.8749933*Vds+-0.054768667*Lg+0.62785167);
hc1_6 = tanh(0.5449184*Vgs+-4.409165*Vds+-0.072947875*Lg+-0.31324536);
hc1_7 = tanh(-2.9224303*Vgs+2.7675478*Vds+0.08862238*Lg+0.6493558);
hc1_8 = tanh(0.65050656*Vgs+-0.29751927*Vds+0.1571876*Lg+-0.38088372);
hc1_9 = tanh(-0.30384183*Vgs+0.5649165*Vds+2.6806898*Lg+0.3197917);
hc1_10 = tanh(-0.095988505*Vgs+2.0158541*Vds+-0.42972717*Lg+-0.30388466);
hc1_11 = tanh(6.7699738*Vgs+-0.07234483*Vds+-0.013545353*Lg+-1.3694142);
hc1_12 = tanh(-0.3404029*Vgs+0.0443459*Vds+0.89597*Lg+0.069993004);
hc1_13 = tanh(0.62300175*Vgs+-0.29515797*Vds+1.6753465*Lg+-0.6520838);
hc1_14 = tanh(0.37957156*Vgs+0.2237372*Vds+0.08591952*Lg+0.13126835);
hc1_15 = tanh(0.19949242*Vgs+-0.26481664*Vds+-0.41059187*Lg+-0.40832308);
hc1_16 = tanh(0.98966587*Vgs+-0.24259183*Vds+0.36584845*Lg+-0.8024042);

hc2_0 = tanh(-0.91327864*hc1_0+0.4696781*hc1_1+0.3302202*hc1_2+0.11393868*hc1_3+0.45070222*hc1_4+-0.2894044*hc1_5+0.55066*hc1_6+-1.6242687*hc1_7+-0.38140613*hc1_8+0.032771554*hc1_9+0.17647126);
hc2_1 = tanh(-1.1663305*hc1_0+-0.523984*hc1_1+-0.90804136*hc1_2+-0.7418044*hc1_3+1.456171*hc1_4+-0.16802542*hc1_5+0.8235596*hc1_6+-2.2246246*hc1_7+-0.40805355*hc1_8+0.7207601*hc1_9+0.4729169);
hc2_2 = tanh(-0.69065374*hc1_0+0.40205315*hc1_1+-0.49410668*hc1_2+0.8681325*hc1_3+0.471351*hc1_4+0.46939445*hc1_5+0.45568785*hc1_6+-0.92935294*hc1_7+-0.8209646*hc1_8+0.1158967*hc1_9+-0.075798474);
hc2_3 = tanh(0.11535446*hc1_0+-0.06296927*hc1_1+-0.6740435*hc1_2+0.7428315*hc1_3+0.05890677*hc1_4+0.9579441*hc1_5+-0.037319*hc1_6+-0.18491426*hc1_7+-0.02981994*hc1_8+0.038347963*hc1_9+0.039531134);
hc2_4 = tanh(0.37817463*hc1_0+-0.6811279*hc1_1+1.1388369*hc1_2+0.19983096*hc1_3+-0.20415118*hc1_4+1.3022176*hc1_5+0.22571652*hc1_6+0.1690611*hc1_7+-0.56475276*hc1_8+-0.4069731*hc1_9+0.99962974);
hc2_5 = tanh(0.032873478*hc1_0+-0.05209407*hc1_1+-0.010839908*hc1_2+-0.13892579*hc1_3+-0.050480977*hc1_4+0.0127089145*hc1_5+0.0052771433*hc1_6+0.02029242*hc1_7+-0.08705659*hc1_8+0.0254766*hc1_9+0.025135752);
hc2_6 = tanh(-0.34639204*hc1_0+0.06937975*hc1_1+0.18671949*hc1_2+-0.18912783*hc1_3+0.1312504*hc1_4+0.4627272*hc1_5+-0.42590702*hc1_6+-0.10966313*hc1_7+0.66083515*hc1_8+-0.050718334*hc1_9+0.08234678);
hc2_7 = tanh(0.90656275*hc1_0+-0.037281644*hc1_1+0.77237594*hc1_2+1.4710428*hc1_3+0.13597831*hc1_4+-0.059844542*hc1_5+-0.7801535*hc1_6+3.7814677*hc1_7+-0.5976644*hc1_8+0.2721995*hc1_9+0.023777716);
hc2_8 = tanh(0.39720625*hc1_0+-0.45262313*hc1_1+0.19873238*hc1_2+0.9750888*hc1_3+-0.9427992*hc1_4+0.4487432*hc1_5+-0.3372945*hc1_6+0.33729544*hc1_7+-0.1667088*hc1_8+-0.5707525*hc1_9+0.27954483);
hc2_9 = tanh(0.28551984*hc1_0+-0.68350387*hc1_1+0.9916423*hc1_2+-0.8254094*hc1_3+0.09875706*hc1_4+0.47609732*hc1_5+-0.058662917*hc1_6+0.09181381*hc1_7+0.09592329*hc1_8+1.3940467*hc1_9+0.3865768);
hc2_10 = tanh(0.098737516*hc1_0+0.060473576*hc1_1+0.42824662*hc1_2+0.15018038*hc1_3+0.082621895*hc1_4+-0.00019039502*hc1_5+-0.3321634*hc1_6+0.7936295*hc1_7+-0.041197542*hc1_8+0.6530619*hc1_9+0.1338804);
hc2_11 = tanh(-0.3585284*hc1_0+-0.09956017*hc1_1+0.17224246*hc1_2+-0.016925728*hc1_3+-0.46462816*hc1_4+-0.5649022*hc1_5+1.251695*hc1_6+-0.4303161*hc1_7+0.48546878*hc1_8+0.22958975*hc1_9+-0.27899802);
hc2_12 = tanh(0.8565631*hc1_0+-0.7622999*hc1_1+0.32367912*hc1_2+1.4776785*hc1_3+0.2712369*hc1_4+0.2275511*hc1_5+0.39908803*hc1_6+4.2305493*hc1_7+-0.3467536*hc1_8+0.41231114*hc1_9+0.47123823);
hc2_13 = tanh(-0.26411077*hc1_0+-0.17583853*hc1_1+0.045439184*hc1_2+-0.13801138*hc1_3+0.03278085*hc1_4+-0.45625108*hc1_5+-0.17905861*hc1_6+0.3060186*hc1_7+-0.3361926*hc1_8+-0.050055273*hc1_9+0.17996444);
hc2_14 = tanh(0.016094366*hc1_0+-0.013196736*hc1_1+0.4124856*hc1_2+0.22926371*hc1_3+-0.35071182*hc1_4+-0.34217188*hc1_5+-0.69466996*hc1_6+1.0563152*hc1_7+-0.18019852*hc1_8+0.061871335*hc1_9+0.09762555);
hc2_15 = tanh(-0.18970782*hc1_0+0.3624813*hc1_1+-1.3419824*hc1_2+0.103635244*hc1_3+-0.14595217*hc1_4+-0.1899393*hc1_5+0.176524*hc1_6+-0.4428012*hc1_7+-0.39544868*hc1_8+-0.45783517*hc1_9+0.1884755);
hc2_16 = tanh(-0.1585831*hc1_0+0.035894837*hc1_1+-0.14261873*hc1_2+0.25914294*hc1_3+0.040607046*hc1_4+0.11555795*hc1_5+0.0022548323*hc1_6+-0.002149359*hc1_7+0.07067297*hc1_8+0.019578662*hc1_9+0.16657573);
yc = 0.17503543*hc2_0+-0.15556754*hc2_1+-0.125455*hc2_2+-0.07502612*hc2_3+-0.16671115*hc2_4+0.29854503;

Cgg = (yc / normO + MinO)*W;
Cgsd = Cgg/2 ;

//******************** I-V NN **********************************//
h1_0 = tanh(0.0023826673*Vgs+-0.0009636134*Vds+0.006639037*Lg+-0.0004692053);
h1_1 = tanh(-7.8007555*Vgs+2.639791*Vds+-0.025273597*Lg+-1.1747514);
h1_2 = tanh(1.9884652*Vgs+0.62111*Vds+-0.11525345*Lg+-0.14575638);
h1_3 = tanh(0.10625471*Vgs+0.09442053*Vds+-0.052119628*Lg+1.1568379);
h1_4 = tanh(4.058087*Vgs+-0.7568158*Vds+0.008070099*Lg+-0.4820452);
h1_5 = tanh(-1.3065948*Vgs+-0.0492497*Vds+-0.081622526*Lg+0.20351954);
h1_6 = tanh(-2.9507525*Vgs+-0.91150546*Vds+-0.06477873*Lg+0.09646383);
h1_7 = tanh(-0.5886177*Vgs+0.63788587*Vds+-0.13710928*Lg+0.30260038);
h1_8 = tanh(-0.4311161*Vgs+-0.7250705*Vds+-0.06134645*Lg+0.44054285);
h1_9 = tanh(0.012132638*Vgs+-0.42545322*Vds+-0.66478956*Lg+0.13182367);
h1_10 = tanh(3.289041e-05*Vgs+0.0011367714*Vds+-0.0051904405*Lg+5.4112927e-05);
h1_11 = tanh(-0.6007774*Vgs+0.09259224*Vds+0.2170182*Lg+-0.2908748);
h1_12 = tanh(0.28018302*Vgs+1.3014064*Vds+-0.13490067*Lg+-0.22006753);
h1_13 = tanh(0.01864017*Vgs+-13.0928755*Vds+-0.0037254083*Lg+-0.10935691);
h1_14 = tanh(-0.0049708197*Vgs+0.0022613218*Vds+-0.014408149*Lg+0.0011340647);
h1_15 = tanh(-0.094654046*Vgs+-0.4174114*Vds+0.18892045*Lg+0.05248958);
h1_16 = tanh(-0.25090316*Vgs+-0.11111481*Vds+-0.009133225*Lg+0.08377026);
h1_17 = tanh(0.9275306*Vgs+0.40686756*Vds+0.14127344*Lg+-0.059246097);
h1_18 = tanh(-0.27084363*Vgs+0.07915911*Vds+-10.836302*Lg+-1.1535788);
h1_19 = tanh(1.6852072*Vgs+-0.24846223*Vds+0.049734037*Lg+-0.19625053);

h2_0 = tanh(1.1139417*h1_0+-0.40033522*h1_1+0.920759*h1_2+0.47607598*h1_3+0.3978683*h1_4+0.8008105*h1_5+-0.40445566*h1_6+0.8668027*h1_7+0.23365597*h1_8+-0.28254375*h1_9+-0.63985884*h1_10+-0.62523574*h1_11+0.8338383*h1_12+-2.0540943*h1_13+1.0749483*h1_14+-1.1075479*h1_15+0.60926706*h1_16+1.1118286*h1_17+-0.8917559*h1_18+0.029025732*h1_19+0.6622382);
h2_1 = tanh(0.37195024*h1_0+-0.761445*h1_1+0.6514153*h1_2+0.6211995*h1_3+-0.063539445*h1_4+0.31260127*h1_5+-0.3529579*h1_6+0.50422627*h1_7+0.18943883*h1_8+-0.38029787*h1_9+-0.3464503*h1_10+-0.48301366*h1_11+0.081978925*h1_12+-0.08305682*h1_13+-0.08420117*h1_14+-0.8029313*h1_15+-0.37052512*h1_16+0.4553502*h1_17+-0.71959645*h1_18+-0.17320661*h1_19+0.6566257);
h2_2 = tanh(-0.021933522*h1_0+-0.017245224*h1_1+0.030417712*h1_2+0.2967218*h1_3+-0.048668377*h1_4+0.029245213*h1_5+0.011756416*h1_6+0.004705658*h1_7+-0.042515088*h1_8+0.010462476*h1_9+0.001331279*h1_10+0.1694541*h1_11+-0.010949079*h1_12+-0.004144526*h1_13+0.04856694*h1_14+-0.010465159*h1_15+0.24588406*h1_16+-0.028521152*h1_17+0.12161568*h1_18+0.1753255*h1_19+-0.09125355);
h2_3 = tanh(-0.025546636*h1_0+-3.2702503*h1_1+0.46812135*h1_2+-0.25135994*h1_3+3.0725436*h1_4+0.22513995*h1_5+-1.0327209*h1_6+-0.56274736*h1_7+0.4726107*h1_8+0.38182434*h1_9+0.016403453*h1_10+-0.09128962*h1_11+0.20997792*h1_12+-0.4951615*h1_13+0.026481293*h1_14+0.6085288*h1_15+-0.09078652*h1_16+0.36613584*h1_17+0.26257026*h1_18+0.39794916*h1_19+-0.52920526);
h2_4 = tanh(-0.44392154*h1_0+-0.5650475*h1_1+0.91716766*h1_2+0.96703196*h1_3+0.4597048*h1_4+1.452921*h1_5+-0.8115141*h1_6+0.92326456*h1_7+0.2862403*h1_8+-0.9441585*h1_9+0.22188367*h1_10+-1.0092766*h1_11+0.5495966*h1_12+0.44870532*h1_13+0.48705962*h1_14+-0.6957133*h1_15+0.27711377*h1_16+1.0138507*h1_17+-0.34337458*h1_18+-0.21548931*h1_19+0.42685974);
h2_5 = tanh(0.0003710325*h1_0+0.5746112*h1_1+0.4144258*h1_2+0.04459103*h1_3+1.2373503*h1_4+0.12786175*h1_5+-0.16099685*h1_6+0.9826207*h1_7+-0.09701193*h1_8+-0.4379135*h1_9+-0.0035542254*h1_10+0.04205593*h1_11+0.65820116*h1_12+0.3810506*h1_13+0.0004259507*h1_14+-0.21782044*h1_15+-0.057544652*h1_16+0.24420041*h1_17+-0.10138292*h1_18+-0.2387106*h1_19+0.867847);
h2_6 = tanh(-0.0077049686*h1_0+-0.05349668*h1_1+-0.11536639*h1_2+0.06141029*h1_3+-0.034344573*h1_4+0.21672213*h1_5+-0.09835135*h1_6+-0.25849992*h1_7+0.10576329*h1_8+-0.14288934*h1_9+0.027846925*h1_10+-0.20104973*h1_11+0.24784875*h1_12+0.03396087*h1_13+-0.016039118*h1_14+-0.03147038*h1_15+-0.023109786*h1_16+-0.118931994*h1_17+0.18256636*h1_18+0.09981429*h1_19+0.079372324);
h2_7 = tanh(-0.009369999*h1_0+-2.4468672*h1_1+-0.41433397*h1_2+-0.6289744*h1_3+-1.8285819*h1_4+0.12905455*h1_5+0.83588725*h1_6+0.11491322*h1_7+0.3871084*h1_8+0.07153052*h1_9+0.013530584*h1_10+0.40614852*h1_11+0.10340061*h1_12+-0.04473306*h1_13+0.0075287875*h1_14+0.5593612*h1_15+0.34401885*h1_16+-0.5538749*h1_17+0.36615464*h1_18+-0.2666981*h1_19+0.20194086);
h2_8 = tanh(-0.0017045025*h1_0+-1.1388719*h1_1+0.25932005*h1_2+-0.6482845*h1_3+2.263395*h1_4+0.115192235*h1_5+-0.40946937*h1_6+-0.038117886*h1_7+-0.03703431*h1_8+0.05965774*h1_9+0.0032721795*h1_10+0.2561857*h1_11+0.47324425*h1_12+-0.25200802*h1_13+0.0017081021*h1_14+0.29819545*h1_15+0.061945435*h1_16+0.13516657*h1_17+0.5409335*h1_18+-0.17400871*h1_19+0.11659722);
h2_9 = tanh(0.014866875*h1_0+1.0399909*h1_1+1.0108095*h1_2+-0.0918755*h1_3+-0.7634763*h1_4+-0.49749368*h1_5+-0.7020006*h1_6+-0.16384888*h1_7+-0.07833025*h1_8+-0.23745225*h1_9+-0.023095092*h1_10+-0.29244414*h1_11+0.6255917*h1_12+0.41413808*h1_13+-0.019823061*h1_14+-1.0593235*h1_15+-0.42221433*h1_16+0.98025715*h1_17+-0.71444243*h1_18+0.84347373*h1_19+0.28510216);
h2_10 = tanh(-0.013515852*h1_0+0.68840384*h1_1+-0.030184174*h1_2+-0.48098114*h1_3+0.08609854*h1_4+-0.50878614*h1_5+0.26547763*h1_6+-0.7151076*h1_7+0.111288495*h1_8+0.53379977*h1_9+0.022258151*h1_10+0.16971351*h1_11+-1.2486296*h1_12+0.9649942*h1_13+0.0028906881*h1_14+0.31582054*h1_15+0.24213083*h1_16+-0.27242163*h1_17+0.11330636*h1_18+0.17038865*h1_19+-0.42089102);
h2_11 = tanh(-0.009949424*h1_0+-0.6704206*h1_1+0.13177924*h1_2+0.07316155*h1_3+-0.28207502*h1_4+-0.32401362*h1_5+0.020746209*h1_6+-0.05517531*h1_7+0.10340257*h1_8+0.29381263*h1_9+0.020497978*h1_10+0.031984854*h1_11+0.079552434*h1_12+-7.7884445*h1_13+0.01224806*h1_14+0.8700812*h1_15+-0.16562358*h1_16+0.14370379*h1_17+0.2389181*h1_18+-0.19771136*h1_19+0.33039534);
h2_12 = tanh(-0.002431529*h1_0+0.30154988*h1_1+-0.45072728*h1_2+0.27823612*h1_3+-0.25173753*h1_4+-0.58188903*h1_5+0.39836177*h1_6+-0.060329597*h1_7+0.1667837*h1_8+-0.09419194*h1_9+0.0108116735*h1_10+-0.3581154*h1_11+0.15690842*h1_12+-0.41209573*h1_13+-0.0070331707*h1_14+-0.23976392*h1_15+0.16620094*h1_16+-0.034617994*h1_17+0.32754526*h1_18+0.8490298*h1_19+0.026407415);
h2_13 = tanh(-0.7385622*h1_0+-0.25174448*h1_1+2.090295*h1_2+0.67499936*h1_3+0.07392262*h1_4+0.5413692*h1_5+-0.8287433*h1_6+2.2810504*h1_7+1.1917778*h1_8+1.3719273*h1_9+0.25762329*h1_10+-2.1111712*h1_11+1.6987114*h1_12+-0.437825*h1_13+1.7649944*h1_14+-2.2254016*h1_15+-2.3555171*h1_16+-0.7732424*h1_17+-1.0756916*h1_18+-0.1367373*h1_19+1.5085722);
h2_14 = tanh(-0.002535408*h1_0+-4.2686224*h1_1+-0.045537975*h1_2+0.08043166*h1_3+1.7274952*h1_4+-0.1260494*h1_5+-0.23011239*h1_6+-0.21025337*h1_7+0.48537356*h1_8+0.39049447*h1_9+-0.006565428*h1_10+-0.293028*h1_11+-1.1253971*h1_12+-0.2890831*h1_13+0.0042421576*h1_14+0.4230598*h1_15+-0.17869289*h1_16+-0.034056116*h1_17+0.61135995*h1_18+0.6345532*h1_19+0.73144835);
h2_15 = tanh(-0.5239093*h1_0+0.49806875*h1_1+0.53555894*h1_2+1.2645539*h1_3+1.011548*h1_4+0.39209503*h1_5+-0.78194916*h1_6+0.94610345*h1_7+0.9121405*h1_8+-1.4693716*h1_9+-0.58336824*h1_10+-1.1661471*h1_11+-0.16158457*h1_12+0.058512915*h1_13+1.3358645*h1_14+0.5742125*h1_15+-1.3325212*h1_16+1.1804186*h1_17+-1.4877121*h1_18+0.6357802*h1_19+1.1328585);
h2_16 = tanh(0.0095406*h1_0+-0.53232694*h1_1+0.1535685*h1_2+0.26108417*h1_3+-0.08375187*h1_4+0.3462123*h1_5+-0.61755395*h1_6+0.0015145333*h1_7+-0.108780764*h1_8+0.2555477*h1_9+0.00023940884*h1_10+-0.26577523*h1_11+-0.27689674*h1_12+0.43049082*h1_13+-0.025424613*h1_14+0.24634649*h1_15+-0.22579487*h1_16+0.37249807*h1_17+-0.8058662*h1_18+-0.77451354*h1_19+0.5821276);
y = -0.17525196*h2_0+-0.22995844*h2_1+0.0026147955*h2_2+0.091129646*h2_3+-0.4534783*h2_4+0.4119419*h2_5+-1.4205361e-05*h2_6+-0.11359831*h2_7+0.1762025*h2_8+-0.1002102*h2_9+-0.37161925*h2_10+0.2683793*h2_11+0.051897053*h2_12+0.19354156*h2_13+-0.10134394*h2_14+0.3937854*h2_15+-0.3296008*h2_16+0.3220947;

        Id = pow(10, (y/normI + MinI)) ;

if (Id <= 1e-15) begin //limit
        Id = 1e-15;
        //Id = Id;
end
else begin
        Id = Id;
end  //limit end

        I(g, d) <+ Cgsd*ddt(Vg-Vd) ;
        I(g, s) <+ Cgsd*ddt(Vg-Vs) ;

if (Vgsraw >= Vgdraw) begin
        I(d, s) <+ dir*Id*W ;

end

else begin
        I(d, s) <+ dir*Id*W ;

end

end

endmodule
