module IWO_verilogA (d, g, s);
inout d, g, s;
electrical d, g, s;

//****** Parameters L and W ********
parameter real W = 0.25;
parameter real L = 0.6;
parameter MinVg = -6.0 ;
parameter normVg = 0.05555555555555555 ;
parameter MinVd = 0.05 ;
parameter normVd = 0.08368200836820085 ;
parameter MinTemperature = 25 ;
parameter normTemperature = 0.016666666666666666 ;
parameter MinI = -14.614393726401689 ;
parameter normI =0.0975145951626748;
parameter vth =0;
parameter real Temp = 25; //set on cadence as variable, 25, 55, 85 Celcius

real Vg, Vd, Vs, Vgs, Vds, Lg, Id, Cgg, Cgs,Cgd, Vgd, temp;
real y, y_cgg, y_cgs, y_cgd, yvth;
real Vgs_cgg, Vgs_cgs, Vgs_cgd;
real Vds_cgg, Vds_cgs, Vds_cgd;
real Lg_cgg, Lg_cgs, Lg_cgd;
real Vgsraw, Vgdraw, dir;
real Vdi, Vsi;

analog begin
	Vg = V(g);
	Vs = V(s);
	Vd = V(d);
    Vgsraw = Vg-Vs ;
    Vgdraw = Vg-Vd ;
if (Vgsraw>=Vgdraw) begin
	Vgs = ((Vg-Vs) - MinVg) * normVg ;
    dir = 1 ;
end
else begin
	Vgs = ((Vg-Vd) - MinVg) * normVg ;
    dir = -1 ;
end
	Vds = (abs(Vd-Vs) - MinVd) * normVd ;
    Temperature = (Temperature - MinTemperature) * normTemperature ;

h1_0 = tanh(1.3682936*Vgs+0.10864725*Vds+0.09570831*temp+-0.56370336);
h1_1 = tanh(0.35757086*Vgs+-0.3125519*Vds+-0.077800125*temp+0.06512575);
h1_2 = tanh(-3.467709*Vgs+0.1477079*Vds+-0.35400343*temp+0.56840074);
h1_3 = tanh(-0.41761824*Vgs+0.37827784*Vds+0.009629602*temp+-0.08403502);
h1_4 = tanh(0.077388346*Vgs+-0.13592862*Vds+-0.49125296*temp+-0.47875088);
h1_5 = tanh(1.7685989*Vgs+0.21931557*Vds+0.045224447*temp+-0.696139);
h1_6 = tanh(0.28883797*Vgs+2.7168286*Vds+-0.014564195*temp+0.035920236);
h1_7 = tanh(-0.28651348*Vgs+-9.313321*Vds+-0.018356342*temp+-0.085513815);
h1_8 = tanh(0.21481839*Vgs+0.48261166*Vds+-0.47899178*temp+0.02021197);
h1_9 = tanh(0.3764944*Vgs+-0.017693995*Vds+0.032974098*temp+-0.13071771);
h1_10 = tanh(1.6996965*Vgs+0.18676242*Vds+0.025404718*temp+-0.55340487);
h1_11 = tanh(-0.4527269*Vgs+12.459189*Vds+0.013352115*temp+0.3704853);
h1_12 = tanh(0.15709274*Vgs+0.42546245*Vds+0.039602395*temp+0.28179026);
h1_13 = tanh(0.55895686*Vgs+1.0040058*Vds+-0.05267897*temp+-0.29336983);
h1_14 = tanh(4.2247148*Vgs+-0.52595556*Vds+-0.12711817*temp+-0.5976594);
h1_15 = tanh(0.050546605*Vgs+-0.330268*Vds+-0.06530699*temp+0.090546615);
h1_16 = tanh(0.9399727*Vgs+0.0031915598*Vds+-1.8324652*temp+-0.2205463);
h1_17 = tanh(-0.36686787*Vgs+-0.11064151*Vds+-0.042833354*temp+-0.06403406);
h1_18 = tanh(-3.3207998*Vgs+-0.25093615*Vds+-0.14441161*temp+0.68027735);
h1_19 = tanh(0.22013985*Vgs+0.16096348*Vds+0.12568545*temp+-0.19767043);
h1_20 = tanh(-0.35515684*Vgs+0.053924657*Vds+-0.0077392324*temp+0.057896234);
h1_21 = tanh(-0.3571371*Vgs+0.30318564*Vds+0.14166854*temp+-0.0015784041);
h1_22 = tanh(-2.0759382*Vgs+0.21130794*Vds+-0.2811531*temp+0.59296787);
h1_23 = tanh(-1.8778507*Vgs+1.8716447*Vds+-0.009100372*temp+0.49192002);
h1_24 = tanh(0.30428374*Vgs+-0.015096752*Vds+-0.25874755*temp+-0.5299717);

h2_0 = tanh(-0.15121306*h1_0+0.13216132*h1_1+-0.06536988*h1_2+-0.07753303*h1_3+-0.0627017*h1_4+0.30817467*h1_5+0.11937187*h1_6+-0.09046796*h1_7+0.24907851*h1_8+-0.16025625*h1_9+-0.05446359*h1_10+-0.09405452*h1_11+0.34127882*h1_12+-0.28119335*h1_13+-0.021876749*h1_14+0.118707955*h1_15+-0.104816854*h1_16+0.25671437*h1_17+0.1401316*h1_18+-0.17812668*h1_19+0.13694039*h1_20+0.24994308*h1_21+-0.11344952*h1_22+-0.027708618*h1_23+0.21742071*h1_24+-0.076762326);
h2_1 = tanh(-0.78145427*h1_0+0.38053373*h1_1+0.63497144*h1_2+-0.55272585*h1_3+-0.373359*h1_4+-0.7319228*h1_5+-0.05778615*h1_6+-0.33025324*h1_7+0.109700605*h1_8+-0.33131123*h1_9+-0.8748794*h1_10+-0.79402417*h1_11+0.16941217*h1_12+-0.73933774*h1_13+-1.0077897*h1_14+0.39914912*h1_15+-0.06262417*h1_16+-0.187232*h1_17+0.74213463*h1_18+-0.48632947*h1_19+-0.09713008*h1_20+-0.034007765*h1_21+0.5337477*h1_22+-0.28644073*h1_23+-0.41770694*h1_24+0.3940315);
h2_2 = tanh(-0.14617051*h1_0+0.25919902*h1_1+-0.5032373*h1_2+-0.07702238*h1_3+0.3340654*h1_4+-0.37784195*h1_5+-0.32679927*h1_6+0.05280126*h1_7+-0.31073138*h1_8+-0.068601824*h1_9+0.255499*h1_10+-0.68618524*h1_11+0.009995105*h1_12+-0.23976146*h1_13+0.3596561*h1_14+0.27053067*h1_15+0.03925609*h1_16+0.014708283*h1_17+-0.50378793*h1_18+-0.325128*h1_19+0.056111608*h1_20+-0.3846926*h1_21+-0.31956074*h1_22+0.018524071*h1_23+0.2912199*h1_24+-0.17706223);
h2_3 = tanh(1.0192437*h1_0+0.2952312*h1_1+-0.7184485*h1_2+-0.15942204*h1_3+-0.22898962*h1_4+1.3602419*h1_5+0.4147001*h1_6+-0.32613468*h1_7+0.118665*h1_8+0.5156584*h1_9+1.6330078*h1_10+-0.18999998*h1_11+-0.24546975*h1_12+0.59235495*h1_13+-0.46896648*h1_14+0.011898787*h1_15+0.13594724*h1_16+-0.06423594*h1_17+-0.5831111*h1_18+0.26271695*h1_19+-0.27697167*h1_20+-0.5960629*h1_21+-0.47877562*h1_22+-0.2673843*h1_23+0.44113356*h1_24+0.15833028);
h2_4 = tanh(0.17485787*h1_0+-0.25197658*h1_1+0.28340328*h1_2+0.16298757*h1_3+0.46007058*h1_4+0.553364*h1_5+-0.16016534*h1_6+1.0048313*h1_7+-0.3832989*h1_8+0.09607217*h1_9+0.27223524*h1_10+-1.6277565*h1_11+-0.44554186*h1_12+-0.15214185*h1_13+-0.28318292*h1_14+-0.08641726*h1_15+-0.160874*h1_16+0.30158028*h1_17+0.3493247*h1_18+0.10298933*h1_19+0.31361485*h1_20+0.08613576*h1_21+0.061518542*h1_22+-0.16366996*h1_23+0.54973364*h1_24+-0.14373721);
h2_5 = tanh(0.33935156*h1_0+-0.08764859*h1_1+0.08953759*h1_2+-0.05985805*h1_3+0.05981396*h1_4+-0.011299745*h1_5+-0.02944149*h1_6+0.20493864*h1_7+-0.116612725*h1_8+-0.15411314*h1_9+-0.2864036*h1_10+0.15415801*h1_11+-0.021363351*h1_12+0.093431406*h1_13+-0.10056162*h1_14+0.16345838*h1_15+0.0015177551*h1_16+-0.17144275*h1_17+-0.32250997*h1_18+-0.40101108*h1_19+-0.24455239*h1_20+-0.030690923*h1_21+0.032743175*h1_22+0.09200769*h1_23+-0.009600082*h1_24+-0.017085247);
h2_6 = tanh(0.0015024132*h1_0+0.11969699*h1_1+0.059993733*h1_2+0.14998081*h1_3+-0.18102922*h1_4+-0.15189783*h1_5+-0.013850557*h1_6+0.052810382*h1_7+-0.038621705*h1_8+0.37050495*h1_9+0.12435658*h1_10+0.04176931*h1_11+0.25870085*h1_12+-0.17529541*h1_13+0.0032982996*h1_14+-0.020419518*h1_15+0.000102264756*h1_16+-0.047449198*h1_17+-0.081498176*h1_18+0.0023551183*h1_19+-0.29558685*h1_20+-0.31671983*h1_21+0.10424289*h1_22+0.12005399*h1_23+0.20814547*h1_24+-0.12134417);
h2_7 = tanh(0.3694447*h1_0+0.73069036*h1_1+0.27723643*h1_2+-0.4362233*h1_3+-0.3097266*h1_4+0.5422265*h1_5+0.3272098*h1_6+-0.25918573*h1_7+-0.24368867*h1_8+0.5618453*h1_9+0.5242211*h1_10+0.08813855*h1_11+0.6799796*h1_12+-0.3979165*h1_13+-0.1711708*h1_14+0.13701682*h1_15+-0.24496073*h1_16+-0.71914124*h1_17+-0.124262586*h1_18+0.084907345*h1_19+-0.81107986*h1_20+-0.042808235*h1_21+-0.25911286*h1_22+0.5207043*h1_23+-0.68941134*h1_24+0.62509125);
h2_8 = tanh(-0.23667358*h1_0+0.21428381*h1_1+-0.17944007*h1_2+-0.53466874*h1_3+-0.26333508*h1_4+-0.31620276*h1_5+-0.6176817*h1_6+0.94770783*h1_7+-0.59175736*h1_8+-0.08227842*h1_9+-0.266288*h1_10+-2.1777353*h1_11+-0.09606042*h1_12+-0.42297733*h1_13+0.5187814*h1_14+0.49746162*h1_15+0.05113266*h1_16+0.12460591*h1_17+-0.22088951*h1_18+-0.049250767*h1_19+-0.16544543*h1_20+-0.3502534*h1_21+0.099300504*h1_22+-0.21233742*h1_23+0.17207603*h1_24+0.1050419);
h2_9 = tanh(1.6620463*h1_0+0.32206154*h1_1+-3.1514213*h1_2+-0.32244164*h1_3+0.51665545*h1_4+2.200411*h1_5+0.18448223*h1_6+-0.091657795*h1_7+-0.11602166*h1_8+0.2834186*h1_9+1.9558989*h1_10+0.57678777*h1_11+0.13611092*h1_12+0.4963337*h1_13+1.5979456*h1_14+-0.06201662*h1_15+0.8314393*h1_16+0.059594274*h1_17+-1.8551767*h1_18+0.31630987*h1_19+-0.28522167*h1_20+-0.16381645*h1_21+-1.4269335*h1_22+-0.2152464*h1_23+0.029742906*h1_24+-0.07692551);
h2_10 = tanh(-0.6429212*h1_0+-0.16028342*h1_1+-0.14567703*h1_2+0.15797648*h1_3+-0.052756388*h1_4+-0.6921917*h1_5+-0.33475283*h1_6+0.015431626*h1_7+0.5116605*h1_8+-0.28691453*h1_9+-0.21460195*h1_10+-0.094519*h1_11+0.3061926*h1_12+-0.43866923*h1_13+0.16803505*h1_14+-0.1590696*h1_15+-0.07571661*h1_16+-0.0147782555*h1_17+0.15124124*h1_18+-0.4375861*h1_19+0.27025503*h1_20+-0.18030754*h1_21+0.33994296*h1_22+0.42213747*h1_23+-0.21455045*h1_24+0.16839875);
h2_11 = tanh(-1.2954369*h1_0+-0.12832154*h1_1+0.3837911*h1_2+0.28372845*h1_3+-0.27130753*h1_4+-1.3768084*h1_5+0.14717877*h1_6+-0.092729814*h1_7+0.3367126*h1_8+-0.24696465*h1_9+-1.0136137*h1_10+-0.004552687*h1_11+-0.28210768*h1_12+-0.4761171*h1_13+-0.90736765*h1_14+-0.056111965*h1_15+-0.2993499*h1_16+0.54925597*h1_17+0.72715276*h1_18+-0.114946246*h1_19+0.44456843*h1_20+0.46368077*h1_21+0.9335892*h1_22+0.55129546*h1_23+0.15040335*h1_24+-0.046020713);
h2_12 = tanh(-0.22911856*h1_0+-0.43084428*h1_1+-0.5708865*h1_2+-0.014085635*h1_3+-0.031142928*h1_4+-0.42261887*h1_5+-0.79023165*h1_6+1.7135651*h1_7+-0.15990627*h1_8+-0.3152476*h1_9+-0.3980455*h1_10+-3.227983*h1_11+-0.5061344*h1_12+-0.26970962*h1_13+0.5441539*h1_14+0.1418216*h1_15+0.03443026*h1_16+0.442166*h1_17+-0.541745*h1_18+0.004449378*h1_19+0.010362773*h1_20+-0.04998462*h1_21+-0.3069243*h1_22+-0.46285695*h1_23+-0.1416931*h1_24+-0.012346868);
h2_13 = tanh(-1.8857709*h1_0+-0.49025315*h1_1+2.9024224*h1_2+0.4528477*h1_3+-0.29217008*h1_4+-1.8506876*h1_5+-0.32379347*h1_6+0.31577328*h1_7+-0.2879506*h1_8+-0.4468048*h1_9+-2.3214548*h1_10+-0.402881*h1_11+-0.02285734*h1_12+-0.5379914*h1_13+-1.4103202*h1_14+0.04002565*h1_15+-0.81248933*h1_16+0.16944006*h1_17+2.2094445*h1_18+-0.334258*h1_19+0.5090875*h1_20+0.36438248*h1_21+1.762124*h1_22+0.57309586*h1_23+0.1488414*h1_24+-0.14031138);
h2_14 = tanh(0.0392183*h1_0+-0.11461049*h1_1+0.08622911*h1_2+0.16133071*h1_3+0.35466343*h1_4+0.15916745*h1_5+-0.34902015*h1_6+-0.014009927*h1_7+-0.15942396*h1_8+0.20350459*h1_9+-0.43946564*h1_10+-0.64061844*h1_11+-0.12759931*h1_12+-0.30195904*h1_13+0.26310438*h1_14+-0.038219254*h1_15+0.3304054*h1_16+0.14586565*h1_17+0.08333233*h1_18+0.17872004*h1_19+-0.0031158226*h1_20+0.30691078*h1_21+0.19418429*h1_22+0.50309086*h1_23+0.35537028*h1_24+-0.3887699);
y = -0.003547749*h2_0+-0.33443508*h2_1+-0.19703725*h2_2+-0.28773198*h2_3+-0.49190745*h2_4+0.00024956328*h2_5+0.0017673661*h2_6+-0.50377244*h2_7+0.18774104*h2_8+0.6415266*h2_9+-0.074222274*h2_10+-0.26616418*h2_11+-0.25925675*h2_12+0.49704534*h2_13+-0.35092828*h2_14+-0.05331843;

Id = pow(10, (y/normI + MinI))*W;
I(g, d) <+ Cgsd*ddt(Vg-Vd) ;
I(g, s) <+ Cgsd*ddt(Vg-Vs) ;

if (Vd >= Vs) begin
	I(d, s) <+ dir*Id;
end

else begin
	I(d, s) <+ dir*Id;
end

end
endmodule
