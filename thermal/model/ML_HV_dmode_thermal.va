// VerilogA for ML_HV, ML_HV_emode, veriloga

`include "constants.vams"
`include "disciplines.vams"

module ML_HV_dmode_thermal(d, g, s);

inout d, g, s;
electrical d, g, s;

//****** Parameters L and W ********
parameter real W = 0.35;
parameter real L = 0.6;
parameter MinVg = -6.0 ;
parameter normVg = 0.05555555555555555 ;
parameter MinVd = 0.05 ;
parameter normVd = 0.08368200836820085 ;
parameter MinTemperature = 25 ;
parameter normTemperature = 0.016666666666666666 ;
parameter MinI = -10.735666307432746 ;
parameter normI = 0.16149346931261227 ;
parameter vth =0;
parameter real Temp = 25; //set on cadence as variable, 25, 55, 85 Celcius

parameter MinVg_cgd = -6.0 ;
parameter normVg_cgd = 0.05555555555555555 ;
parameter MinVd_cgd = -6.0 ;
parameter normVd_cgd = 0.05555555555555555 ;
parameter MinLg_cgd = 0.6 ;
parameter normLg_cgd = 0 ;
parameter MinO_cgd = -13.926054483271312 ;
parameter normO_cgd =1.4486107458852509 ;

parameter MinVg_cgs = -6.0 ;
parameter normVg_cgs = 0.05555555555555555 ;
parameter MinVd_cgs = -6.0 ;
parameter normVd_cgs = 0.05555555555555555 ;
parameter MinLg_cgs = 0.6 ;
parameter normLg_cgs = 0 ;
parameter MinO_cgs = -13.08359343161434 ;
parameter normO_cgs =2.886734269461609;

real Vg, Vd, Vs, Vgs, Vds, Lg, Id, Cgg, Cgs,Cgd, Vgd, temp;
real y, y_cgg, y_cgs, y_cgd, yvth;
real Vgs_cgg, Vgs_cgs, Vgs_cgd;
real Vds_cgg, Vds_cgs, Vds_cgd;
real Lg_cgg, Lg_cgs, Lg_cgd;
real Vgsraw, Vgdraw, dir;
real Vdi, Vsi;

real h1_0, h1_1, h1_2, h1_3, h1_4, h1_5, h1_6, h1_7, h1_8, h1_9, h1_10, h1_11, h1_12, h1_13, h1_14, h1_15, h1_16, h1_17, h1_18, h1_19, h1_20, h1_21, h1_22, h1_23, h1_24;
real h2_0, h2_1, h2_2, h2_3, h2_4, h2_5, h2_6, h2_7, h2_8, h2_9, h2_10, h2_11, h2_12, h2_13, h2_14;
real hcgg1_0, hcgg1_1, hcgg1_2, hcgg1_3, hcgg1_4, hcgg1_5, hcgg1_6, hcgg1_7, hcgg1_8, hcgg1_9, hcgg1_10, hcgg1_11, hcgg1_12, hcgg1_13, hcgg1_14, hcgg1_15, hcgg1_16, hcgg1_17, hcgg1_18, hcgg1_19, hcgg1_20, hcgg1_21, hcgg1_22, hcgg1_23, hcgg1_24;
real hcgg2_0, hcgg2_1, hcgg2_2, hcgg2_3, hcgg2_4, hcgg2_5, hcgg2_6, hcgg2_7, hcgg2_8, hcgg2_9, hcgg2_10, hcgg2_11;
real hcgs1_0, hcgs1_1, hcgs1_2, hcgs1_3, hcgs1_4, hcgs1_5, hcgs1_6, hcgs1_7, hcgs1_8, hcgs1_9, hcgs1_10, hcgs1_11, hcgs1_12, hcgs1_13, hcgs1_14, hcgs1_15, hcgs1_16, hcgs1_17, hcgs1_18, hcgs1_19, hcgs1_20, hcgs1_21, hcgs1_22, hcgs1_23, hcgs1_24;
real hcgs2_0, hcgs2_1, hcgs2_2, hcgs2_3, hcgs2_4, hcgs2_5, hcgs2_6, hcgs2_7, hcgs2_8, hcgs2_9, hcgs2_10, hcgs2_11;
real hcgd1_0, hcgd1_1, hcgd1_2, hcgd1_3, hcgd1_4, hcgd1_5, hcgd1_6, hcgd1_7, hcgd1_8, hcgd1_9, hcgd1_10, hcgd1_11, hcgd1_12, hcgd1_13, hcgd1_14, hcgd1_15, hcgd1_16, hcgd1_17, hcgd1_18, hcgd1_19, hcgd1_20, hcgd1_21, hcgd1_22, hcgd1_23, hcgd1_24;
real hcgd2_0, hcgd2_1, hcgd2_2, hcgd2_3, hcgd2_4, hcgd2_5, hcgd2_6, hcgd2_7, hcgd2_8, hcgd2_9, hcgd2_10, hcgd2_11;

real Qgd, Qgs;

analog begin

	Vg = V(g);
	Vs = V(s);
	Vd = V(d);
    Vgsraw = Vg-Vs ;
    Vgdraw = Vg-Vd ;
if (Vgsraw>=Vgdraw) begin
	Vgs = ((Vg-Vs) - MinVg - vth) * normVg ;

	Vgs_cgs = ((Vg-Vs) - MinVg_cgs - vth) * normVg_cgs ;
	Vgs_cgd = ((Vg-Vs) - MinVg_cgd - vth) * normVg_cgd ;
	dir = 1 ;
end
else begin
	Vgs = ((Vg-Vd) - MinVg - vth) * normVg ;
	Vgs_cgs = ((Vg-Vd) - MinVg_cgs - vth ) * normVg_cgs ;
	Vgs_cgd = ((Vg-Vd) - MinVg_cgd - vth) * normVg_cgd ;
	dir = -1 ;
end

	Vds = (abs(Vd-Vs) - MinVd) * normVd ;
    temp = (Temp - MinTemperature) * normTemperature ;

	Vds_cgs = (abs(Vd-Vs) - MinVd_cgs) * normVd_cgs ;
	Vds_cgd = (abs(Vd-Vs) - MinVd_cgd) * normVd_cgd ;

	Lg_cgs = (L -MinLg_cgs)*normLg_cgs ;
	Lg_cgd = (L -MinLg_cgd)*normLg_cgd ;

hcgd1_0 = tanh(-1.6088891*Vgs_cgd+6.3197856*Vds_cgd+-0.34359035*Lg_cgd+-1.2290763);
hcgd1_1 = tanh(12.800741*Vgs_cgd+-0.7317432*Vds_cgd+-0.13210897*Lg_cgd+-0.9875373);
hcgd1_2 = tanh(-0.0054054493*Vgs_cgd+-0.0007543899*Vds_cgd+0.23912339*Lg_cgd+0.0017988982);
hcgd1_3 = tanh(0.22807486*Vgs_cgd+-0.5850707*Vds_cgd+0.1802489*Lg_cgd+-0.041721515);
hcgd1_4 = tanh(-1.9484413*Vgs_cgd+0.5350963*Vds_cgd+0.094985865*Lg_cgd+0.38261548);
hcgd1_5 = tanh(0.07684944*Vgs_cgd+0.73550975*Vds_cgd+0.24519779*Lg_cgd+-0.33061126);
hcgd1_6 = tanh(-0.89280343*Vgs_cgd+-0.7184284*Vds_cgd+-0.3183667*Lg_cgd+0.8391025);
hcgd1_7 = tanh(-0.39399716*Vgs_cgd+-0.48556596*Vds_cgd+0.03430429*Lg_cgd+-1.3344768);
hcgd1_8 = tanh(-0.3645768*Vgs_cgd+0.28501382*Vds_cgd+0.21822546*Lg_cgd+0.05729416);
hcgd1_9 = tanh(0.16371249*Vgs_cgd+-7.4085484*Vds_cgd+0.16751836*Lg_cgd+0.94246316);
hcgd1_10 = tanh(-0.00981918*Vgs_cgd+1.5533135*Vds_cgd+0.3354165*Lg_cgd+-0.987391);
hcgd1_11 = tanh(-0.8166236*Vgs_cgd+-1.5672101*Vds_cgd+-0.37568504*Lg_cgd+1.5318174);
hcgd1_12 = tanh(0.2171772*Vgs_cgd+0.27744094*Vds_cgd+-0.3758668*Lg_cgd+0.22765432);
hcgd1_13 = tanh(5.4901214*Vgs_cgd+-2.3752038*Vds_cgd+-0.37384644*Lg_cgd+-1.8590863);
hcgd1_14 = tanh(0.0019571404*Vgs_cgd+-0.004179957*Vds_cgd+-0.19047788*Lg_cgd+-0.0013728535);
hcgd1_15 = tanh(0.3415198*Vgs_cgd+-0.7726733*Vds_cgd+-0.2894067*Lg_cgd+0.28510723);
hcgd1_16 = tanh(0.60382843*Vgs_cgd+0.29274306*Vds_cgd+0.3782456*Lg_cgd+-0.42503095);
hcgd1_17 = tanh(-1.4589765*Vgs_cgd+-28.384256*Vds_cgd+0.14227134*Lg_cgd+0.27606094);
hcgd1_18 = tanh(-0.925936*Vgs_cgd+-0.8781763*Vds_cgd+-0.015472701*Lg_cgd+1.0576844);
hcgd1_19 = tanh(-0.24114211*Vgs_cgd+-0.23577656*Vds_cgd+-0.15397707*Lg_cgd+0.21749781);
hcgd1_20 = tanh(-0.10808995*Vgs_cgd+-0.47354648*Vds_cgd+-0.4505364*Lg_cgd+0.20475943);
hcgd1_21 = tanh(0.0030588252*Vgs_cgd+0.0031867356*Vds_cgd+0.36055082*Lg_cgd+0.0012428315);
hcgd1_22 = tanh(-0.5569403*Vgs_cgd+0.49564502*Vds_cgd+-0.3408415*Lg_cgd+0.110713266);
hcgd1_23 = tanh(-8.529932*Vgs_cgd+3.9473457*Vds_cgd+0.18583581*Lg_cgd+1.5164791);
hcgd1_24 = tanh(-0.46144176*Vgs_cgd+0.17818846*Vds_cgd+0.40154326*Lg_cgd+0.013512757);
hcgd2_0 = tanh(-1.2514079*hcgd1_0+1.8445047*hcgd1_1+-0.060258187*hcgd1_2+0.54575056*hcgd1_3+0.27076387*hcgd1_4+-0.7876322*hcgd1_5+0.77317226*hcgd1_6+-0.3889938*hcgd1_7+-0.21885906*hcgd1_8+-1.1528927*hcgd1_9+0.14252257*hcgd1_10+0.740463*hcgd1_11+0.08602427*hcgd1_12+0.7715963*hcgd1_13+-0.101067945*hcgd1_14+0.44884506*hcgd1_15+-0.2603153*hcgd1_16+-0.39788675*hcgd1_17+0.9237374*hcgd1_18+0.39531583*hcgd1_19+0.49464858*hcgd1_20+-0.12488924*hcgd1_21+-0.7705938*hcgd1_22+-0.86613214*hcgd1_23+-0.38659856*hcgd1_24+0.66808015);
hcgd2_1 = tanh(-0.11062574*hcgd1_0+0.083067186*hcgd1_1+-0.037825696*hcgd1_2+0.20563497*hcgd1_3+0.33369613*hcgd1_4+0.0886166*hcgd1_5+0.09043529*hcgd1_6+0.030820973*hcgd1_7+0.33438814*hcgd1_8+-0.039903246*hcgd1_9+0.069336206*hcgd1_10+0.20417899*hcgd1_11+-0.082516894*hcgd1_12+0.024985574*hcgd1_13+0.048390143*hcgd1_14+0.06470794*hcgd1_15+0.02195431*hcgd1_16+0.09177701*hcgd1_17+-0.10868985*hcgd1_18+-0.6351576*hcgd1_19+-0.6435663*hcgd1_20+0.016601902*hcgd1_21+0.11345903*hcgd1_22+-0.106875926*hcgd1_23+-0.22184639*hcgd1_24+0.06259622);
hcgd2_2 = tanh(0.9100889*hcgd1_0+0.8600478*hcgd1_1+-0.0020481474*hcgd1_2+0.07100766*hcgd1_3+-0.47693938*hcgd1_4+0.63060385*hcgd1_5+-1.7883018*hcgd1_6+-0.10218202*hcgd1_7+0.3747722*hcgd1_8+1.0218011*hcgd1_9+0.93496245*hcgd1_10+-1.7450128*hcgd1_11+-0.113168575*hcgd1_12+-0.66238743*hcgd1_13+-0.030654324*hcgd1_14+-0.92108375*hcgd1_15+1.0528872*hcgd1_16+0.033458687*hcgd1_17+-1.3917034*hcgd1_18+-0.35307285*hcgd1_19+-0.48046726*hcgd1_20+-0.014765772*hcgd1_21+0.23623382*hcgd1_22+-2.6411834*hcgd1_23+0.027243387*hcgd1_24+0.03591177);
hcgd2_3 = tanh(0.62506354*hcgd1_0+0.44420892*hcgd1_1+-0.022703474*hcgd1_2+0.77745813*hcgd1_3+0.24668725*hcgd1_4+-0.39535686*hcgd1_5+-0.36517298*hcgd1_6+0.6084278*hcgd1_7+-0.3068207*hcgd1_8+-0.630984*hcgd1_9+-0.76083857*hcgd1_10+0.33673477*hcgd1_11+-0.38794822*hcgd1_12+0.8889784*hcgd1_13+-0.032760695*hcgd1_14+0.31031358*hcgd1_15+0.44298455*hcgd1_16+-1.8597292*hcgd1_17+0.1456184*hcgd1_18+0.29207367*hcgd1_19+0.32642275*hcgd1_20+-0.04083263*hcgd1_21+-0.8064821*hcgd1_22+-0.8100279*hcgd1_23+-0.40088394*hcgd1_24+-0.46441332);
hcgd2_4 = tanh(1.8506681*hcgd1_0+-0.9750525*hcgd1_1+0.003659014*hcgd1_2+-0.6878417*hcgd1_3+-0.5547116*hcgd1_4+0.1308772*hcgd1_5+0.45871595*hcgd1_6+0.15744588*hcgd1_7+0.26718134*hcgd1_8+0.9983965*hcgd1_9+0.5910452*hcgd1_10+0.37368506*hcgd1_11+0.029024748*hcgd1_12+-1.3510306*hcgd1_13+0.0152292065*hcgd1_14+-0.35220924*hcgd1_15+-0.6619339*hcgd1_16+1.342967*hcgd1_17+0.46826208*hcgd1_18+-0.29376435*hcgd1_19+-0.3991243*hcgd1_20+-0.015383459*hcgd1_21+0.85965115*hcgd1_22+0.60075265*hcgd1_23+0.18427542*hcgd1_24+-0.32940418);
hcgd2_5 = tanh(-0.8664879*hcgd1_0+0.44505116*hcgd1_1+0.013057195*hcgd1_2+-0.0031339983*hcgd1_3+0.19921027*hcgd1_4+-0.22984676*hcgd1_5+0.3673192*hcgd1_6+0.56390464*hcgd1_7+-0.034784332*hcgd1_8+-0.4111533*hcgd1_9+-0.118535414*hcgd1_10+0.5688084*hcgd1_11+-0.19346042*hcgd1_12+0.26538432*hcgd1_13+0.0061995205*hcgd1_14+-0.10955226*hcgd1_15+0.015352882*hcgd1_16+-0.16454482*hcgd1_17+0.32237643*hcgd1_18+0.088658795*hcgd1_19+0.20537783*hcgd1_20+0.0050276928*hcgd1_21+-0.015647996*hcgd1_22+-0.2880599*hcgd1_23+0.2548945*hcgd1_24+-0.16771647);
hcgd2_6 = tanh(1.1495414*hcgd1_0+-0.22627151*hcgd1_1+0.015214143*hcgd1_2+0.27357554*hcgd1_3+-0.36256093*hcgd1_4+-0.92208475*hcgd1_5+0.24147213*hcgd1_6+0.38718736*hcgd1_7+-0.41560674*hcgd1_8+0.94879586*hcgd1_9+-0.5408847*hcgd1_10+0.32851028*hcgd1_11+0.040295456*hcgd1_12+-0.033835553*hcgd1_13+0.011123846*hcgd1_14+0.52912486*hcgd1_15+0.03981201*hcgd1_16+-0.30909863*hcgd1_17+0.3929471*hcgd1_18+0.32624614*hcgd1_19+0.8135803*hcgd1_20+0.009368981*hcgd1_21+-0.51490057*hcgd1_22+-0.45729175*hcgd1_23+0.26873454*hcgd1_24+-0.01673438);
hcgd2_7 = tanh(-3.966802*hcgd1_0+0.042795368*hcgd1_1+0.054317914*hcgd1_2+-0.91404206*hcgd1_3+1.1362458*hcgd1_4+-0.07761897*hcgd1_5+1.5529021*hcgd1_6+-0.48278892*hcgd1_7+-0.5192229*hcgd1_8+-0.9233961*hcgd1_9+-0.73843503*hcgd1_10+2.1569836*hcgd1_11+0.7887896*hcgd1_12+1.366921*hcgd1_13+0.07727752*hcgd1_14+0.38954172*hcgd1_15+-0.47272664*hcgd1_16+-0.4188385*hcgd1_17+1.5436481*hcgd1_18+0.1914369*hcgd1_19+-0.024450772*hcgd1_20+0.010537377*hcgd1_21+0.051735442*hcgd1_22+2.4417806*hcgd1_23+-0.50142026*hcgd1_24+0.95721453);
hcgd2_8 = tanh(-0.11731646*hcgd1_0+0.08615463*hcgd1_1+0.013967979*hcgd1_2+-0.3801745*hcgd1_3+0.26075113*hcgd1_4+0.05496182*hcgd1_5+0.26613086*hcgd1_6+0.053695574*hcgd1_7+-0.28042397*hcgd1_8+-0.03794526*hcgd1_9+-0.0068770945*hcgd1_10+0.30859926*hcgd1_11+-0.0229647*hcgd1_12+0.025560087*hcgd1_13+0.017060574*hcgd1_14+-0.25769773*hcgd1_15+0.06637153*hcgd1_16+0.07093841*hcgd1_17+-0.5513341*hcgd1_18+-0.19939162*hcgd1_19+0.08702792*hcgd1_20+0.09092291*hcgd1_21+0.31653336*hcgd1_22+-0.09402478*hcgd1_23+-0.2813343*hcgd1_24+-0.00752968);
hcgd2_9 = tanh(0.110342234*hcgd1_0+-0.0826157*hcgd1_1+-0.14750138*hcgd1_2+-0.24709061*hcgd1_3+-0.25432354*hcgd1_4+-0.09893609*hcgd1_5+-0.015331019*hcgd1_6+0.19696374*hcgd1_7+-0.019382935*hcgd1_8+0.08544908*hcgd1_9+-0.09507841*hcgd1_10+0.11304415*hcgd1_11+0.2705397*hcgd1_12+-0.04126459*hcgd1_13+-0.1613513*hcgd1_14+0.3283118*hcgd1_15+-0.4909294*hcgd1_16+-0.066513576*hcgd1_17+-0.17823151*hcgd1_18+-0.2690935*hcgd1_19+-0.1837275*hcgd1_20+-0.11801412*hcgd1_21+-0.010364476*hcgd1_22+0.088502504*hcgd1_23+-0.10050535*hcgd1_24+-0.06808074);
hcgd2_10 = tanh(-4.403549*hcgd1_0+-2.471523*hcgd1_1+-0.00089143997*hcgd1_2+-0.70052093*hcgd1_3+1.5336959*hcgd1_4+0.034311388*hcgd1_5+0.47960278*hcgd1_6+0.48460782*hcgd1_7+0.14602353*hcgd1_8+-2.0514007*hcgd1_9+0.85300875*hcgd1_10+0.6684621*hcgd1_11+-0.06943985*hcgd1_12+-0.34655583*hcgd1_13+0.024638627*hcgd1_14+-0.07107706*hcgd1_15+-0.6265861*hcgd1_16+-1.1899346*hcgd1_17+0.758323*hcgd1_18+0.078832895*hcgd1_19+-0.3047711*hcgd1_20+0.00015650672*hcgd1_21+0.56323916*hcgd1_22+0.5847528*hcgd1_23+0.07073806*hcgd1_24+-0.15086874);
hcgd2_11 = tanh(0.47815424*hcgd1_0+0.048465684*hcgd1_1+-0.002923328*hcgd1_2+-0.37546745*hcgd1_3+0.66585714*hcgd1_4+0.09604421*hcgd1_5+-1.2400401*hcgd1_6+-1.5856158*hcgd1_7+-0.16395986*hcgd1_8+-0.12747197*hcgd1_9+0.029356737*hcgd1_10+0.10224382*hcgd1_11+0.76213807*hcgd1_12+-1.8363391*hcgd1_13+-0.008269408*hcgd1_14+0.2678933*hcgd1_15+0.46798977*hcgd1_16+-1.9006412*hcgd1_17+-0.4502235*hcgd1_18+-0.09107671*hcgd1_19+-0.2680099*hcgd1_20+-0.010051073*hcgd1_21+0.050625626*hcgd1_22+1.8481784*hcgd1_23+-0.6646883*hcgd1_24+0.9775716);
y_cgd = -0.19379665*hcgd2_0+0.0061848215*hcgd2_1+-0.32997322*hcgd2_2+0.33700317*hcgd2_3+0.19574322*hcgd2_4+0.55552804*hcgd2_5+-0.18057454*hcgd2_6+-0.18055588*hcgd2_7+0.006111857*hcgd2_8+-0.006008425*hcgd2_9+-0.27025312*hcgd2_10+0.58404464*hcgd2_11+-0.059968084;

hcgs1_0 = tanh(0.003866898*Vgs_cgs+-0.0061709154*Vds_cgs+0.07367021*Lg_cgs+0.005350336);
hcgs1_1 = tanh(0.0038147226*Vgs_cgs+-0.006049334*Vds_cgs+-0.17519544*Lg_cgs+0.005365436);
hcgs1_2 = tanh(-0.14925069*Vgs_cgs+0.31913087*Vds_cgs+-0.3709501*Lg_cgs+0.94486016);
hcgs1_3 = tanh(-5.7050853*Vgs_cgs+3.0125842*Vds_cgs+-0.3576562*Lg_cgs+0.6098174);
hcgs1_4 = tanh(0.73557264*Vgs_cgs+0.17232454*Vds_cgs+-0.408028*Lg_cgs+-0.41273043);
hcgs1_5 = tanh(0.47328284*Vgs_cgs+-0.25681034*Vds_cgs+0.16284285*Lg_cgs+-0.033205096);
hcgs1_6 = tanh(1.8763449*Vgs_cgs+-0.9621107*Vds_cgs+0.24538922*Lg_cgs+0.024004985);
hcgs1_7 = tanh(-1.5798868*Vgs_cgs+1.9016485*Vds_cgs+-0.26374397*Lg_cgs+-1.0214508);
hcgs1_8 = tanh(1.8300656*Vgs_cgs+-0.45609108*Vds_cgs+-0.11383694*Lg_cgs+-0.69372463);
hcgs1_9 = tanh(0.0038994814*Vgs_cgs+-0.0062413956*Vds_cgs+0.16813117*Lg_cgs+0.005379745);
hcgs1_10 = tanh(1.6561933*Vgs_cgs+-0.09678654*Vds_cgs+0.4255832*Lg_cgs+-1.0611489);
hcgs1_11 = tanh(-0.28797054*Vgs_cgs+0.13389988*Vds_cgs+0.43625653*Lg_cgs+0.033546243);
hcgs1_12 = tanh(0.8129892*Vgs_cgs+-0.029293621*Vds_cgs+0.1894619*Lg_cgs+-0.4490194);
hcgs1_13 = tanh(0.008404021*Vgs_cgs+-0.5041153*Vds_cgs+0.29847372*Lg_cgs+-0.1161287);
hcgs1_14 = tanh(0.32958084*Vgs_cgs+-0.30009958*Vds_cgs+-0.22462274*Lg_cgs+0.0048046284);
hcgs1_15 = tanh(2.3854203*Vgs_cgs+-3.2975893*Vds_cgs+0.042711172*Lg_cgs+0.53147864);
hcgs1_16 = tanh(0.0039317203*Vgs_cgs+-0.00632388*Vds_cgs+0.28598666*Lg_cgs+0.0053823735);
hcgs1_17 = tanh(0.0037897201*Vgs_cgs+-0.005991189*Vds_cgs+-0.37188497*Lg_cgs+0.0053383214);
hcgs1_18 = tanh(1.8098192*Vgs_cgs+-2.3450627*Vds_cgs+-0.15223776*Lg_cgs+1.3056793);
hcgs1_19 = tanh(-0.01902712*Vgs_cgs+-2.2522266*Vds_cgs+0.42196727*Lg_cgs+1.2842451);
hcgs1_20 = tanh(-1.3350194*Vgs_cgs+0.4994975*Vds_cgs+-0.17475094*Lg_cgs+0.18653236);
hcgs1_21 = tanh(-4.302233*Vgs_cgs+-3.9769611*Vds_cgs+0.07871075*Lg_cgs+3.110047);
hcgs1_22 = tanh(0.023444308*Vgs_cgs+-0.58594865*Vds_cgs+-0.02238914*Lg_cgs+-0.052440178);
hcgs1_23 = tanh(0.15485905*Vgs_cgs+1.2359923*Vds_cgs+-0.15997769*Lg_cgs+-0.2019675);
hcgs1_24 = tanh(-0.3575714*Vgs_cgs+-2.5208488*Vds_cgs+-0.1896365*Lg_cgs+2.4808133);
hcgs2_0 = tanh(0.023202578*hcgs1_0+0.022973271*hcgs1_1+-0.06634169*hcgs1_2+0.7479778*hcgs1_3+-0.29115394*hcgs1_4+0.5281517*hcgs1_5+1.4476869*hcgs1_6+-0.57092524*hcgs1_7+1.342318*hcgs1_8+0.023113564*hcgs1_9+0.5039525*hcgs1_10+-0.28507996*hcgs1_11+0.33107176*hcgs1_12+0.59429955*hcgs1_13+-0.063477024*hcgs1_14+1.4652793*hcgs1_15+0.0230467*hcgs1_16+0.02331026*hcgs1_17+0.067940354*hcgs1_18+1.9354934*hcgs1_19+-0.6783489*hcgs1_20+-0.3415898*hcgs1_21+0.0735886*hcgs1_22+-1.0008856*hcgs1_23+0.009945778*hcgs1_24+-0.2625346);
hcgs2_1 = tanh(0.044127226*hcgs1_0+0.045110825*hcgs1_1+-1.5823554*hcgs1_2+-2.1134062*hcgs1_3+0.279113*hcgs1_4+1.0231125*hcgs1_5+-0.47619388*hcgs1_6+0.64811915*hcgs1_7+-3.5616899*hcgs1_8+0.043715417*hcgs1_9+-0.96364224*hcgs1_10+0.93940836*hcgs1_11+0.90396035*hcgs1_12+2.3027606*hcgs1_13+2.184711*hcgs1_14+1.2926208*hcgs1_15+0.043070372*hcgs1_16+0.04556742*hcgs1_17+-0.99922925*hcgs1_18+0.5443892*hcgs1_19+1.7640798*hcgs1_20+0.57941544*hcgs1_21+3.1087935*hcgs1_22+-0.946341*hcgs1_23+-0.936913*hcgs1_24+-1.4875553);
hcgs2_2 = tanh(0.005477332*hcgs1_0+0.0053486465*hcgs1_1+0.047083233*hcgs1_2+0.5397506*hcgs1_3+-0.075822465*hcgs1_4+0.036040183*hcgs1_5+-0.21352278*hcgs1_6+0.89393115*hcgs1_7+-1.1001998*hcgs1_8+0.005473618*hcgs1_9+-1.1550146*hcgs1_10+-0.070924945*hcgs1_11+-0.16800475*hcgs1_12+-0.1525137*hcgs1_13+-0.06899515*hcgs1_14+-0.051954325*hcgs1_15+0.0054896707*hcgs1_16+0.0054276832*hcgs1_17+-1.158984*hcgs1_18+-0.026913341*hcgs1_19+0.21477942*hcgs1_20+-0.3370402*hcgs1_21+-0.12709796*hcgs1_22+0.5450149*hcgs1_23+-0.19750577*hcgs1_24+-0.45452434);
hcgs2_3 = tanh(0.031963654*hcgs1_0+0.03035919*hcgs1_1+-0.26406923*hcgs1_2+2.4108412*hcgs1_3+0.6478258*hcgs1_4+-0.2639667*hcgs1_5+0.15820932*hcgs1_6+0.36013365*hcgs1_7+-0.07805458*hcgs1_8+0.032406412*hcgs1_9+0.15034798*hcgs1_10+0.04711759*hcgs1_11+0.51302767*hcgs1_12+-0.9524351*hcgs1_13+0.05383534*hcgs1_14+-2.1840389*hcgs1_15+0.033131413*hcgs1_16+0.030272223*hcgs1_17+-0.70434415*hcgs1_18+-1.3847973*hcgs1_19+0.055561617*hcgs1_20+-2.2977886*hcgs1_21+-1.2528052*hcgs1_22+1.6460723*hcgs1_23+0.52855104*hcgs1_24+0.20310849);
hcgs2_4 = tanh(-0.004114148*hcgs1_0+-0.0036210776*hcgs1_1+-0.25540155*hcgs1_2+-0.18470578*hcgs1_3+-0.12067126*hcgs1_4+-0.7038924*hcgs1_5+0.21889566*hcgs1_6+-0.17658989*hcgs1_7+0.1299486*hcgs1_8+-0.0041041495*hcgs1_9+-0.4014189*hcgs1_10+0.20044085*hcgs1_11+-0.19608615*hcgs1_12+0.02296377*hcgs1_13+-0.013663749*hcgs1_14+0.4224307*hcgs1_15+-0.004211446*hcgs1_16+-0.003838226*hcgs1_17+-0.2911345*hcgs1_18+0.78450745*hcgs1_19+0.42747602*hcgs1_20+-0.07747369*hcgs1_21+-0.27040684*hcgs1_22+0.11331162*hcgs1_23+-0.20715222*hcgs1_24+-0.017163113);
hcgs2_5 = tanh(0.011508604*hcgs1_0+0.011453037*hcgs1_1+1.7924933*hcgs1_2+-1.8155463*hcgs1_3+-0.25609693*hcgs1_4+-0.758906*hcgs1_5+-2.4812367*hcgs1_6+4.0513716*hcgs1_7+-2.5917294*hcgs1_8+0.011474304*hcgs1_9+-3.2454631*hcgs1_10+0.093522236*hcgs1_11+-1.3182486*hcgs1_12+-0.8882851*hcgs1_13+-0.9181794*hcgs1_14+1.3970197*hcgs1_15+0.011446857*hcgs1_16+0.011560462*hcgs1_17+-5.1778355*hcgs1_18+-0.2236407*hcgs1_19+2.0796807*hcgs1_20+5.9254537*hcgs1_21+-0.72559786*hcgs1_22+0.45175433*hcgs1_23+-3.1938994*hcgs1_24+0.9409381);
hcgs2_6 = tanh(0.060208883*hcgs1_0+0.057784908*hcgs1_1+-0.4230708*hcgs1_2+0.31358114*hcgs1_3+0.5314662*hcgs1_4+-1.1043811*hcgs1_5+-0.30330408*hcgs1_6+0.5861162*hcgs1_7+-0.2730255*hcgs1_8+0.0608772*hcgs1_9+1.2918353*hcgs1_10+0.5573929*hcgs1_11+0.96025693*hcgs1_12+-1.5764415*hcgs1_13+-1.0071468*hcgs1_14+-2.9516594*hcgs1_15+0.061963964*hcgs1_16+0.057676923*hcgs1_17+-0.12257842*hcgs1_18+-1.6470038*hcgs1_19+0.9465945*hcgs1_20+-0.93217355*hcgs1_21+-2.438695*hcgs1_22+1.0968347*hcgs1_23+0.16981499*hcgs1_24+0.42413175);
hcgs2_7 = tanh(-0.008120307*hcgs1_0+-0.008280249*hcgs1_1+0.17085399*hcgs1_2+1.1467992*hcgs1_3+2.214014*hcgs1_4+1.1809759*hcgs1_5+7.2768965*hcgs1_6+-4.8417068*hcgs1_7+5.984158*hcgs1_8+-0.0075962003*hcgs1_9+2.7736754*hcgs1_10+-1.9165568*hcgs1_11+0.4659055*hcgs1_12+-1.3562847*hcgs1_13+0.48391283*hcgs1_14+-2.8675776*hcgs1_15+-0.007374848*hcgs1_16+-0.00872389*hcgs1_17+-0.1205414*hcgs1_18+-1.7518774*hcgs1_19+-3.7752948*hcgs1_20+0.27624342*hcgs1_21+-1.239815*hcgs1_22+-0.11851393*hcgs1_23+4.030906*hcgs1_24+0.9663557);
hcgs2_8 = tanh(-0.06382305*hcgs1_0+-0.07465671*hcgs1_1+-0.17580509*hcgs1_2+0.039555147*hcgs1_3+-0.3423838*hcgs1_4+0.40099683*hcgs1_5+0.08354397*hcgs1_6+0.049524635*hcgs1_7+0.010591255*hcgs1_8+-0.0655947*hcgs1_9+-0.09075449*hcgs1_10+0.21120805*hcgs1_11+0.18817192*hcgs1_12+-0.37621862*hcgs1_13+-0.11487423*hcgs1_14+0.025681255*hcgs1_15+-0.06386206*hcgs1_16+-0.068342805*hcgs1_17+-0.008454653*hcgs1_18+0.015086431*hcgs1_19+-0.13472116*hcgs1_20+0.025698638*hcgs1_21+0.0998438*hcgs1_22+0.20212452*hcgs1_23+0.05868889*hcgs1_24+-0.10602957);
hcgs2_9 = tanh(0.019189388*hcgs1_0+0.01920859*hcgs1_1+-0.012194334*hcgs1_2+-1.4130874*hcgs1_3+0.30251437*hcgs1_4+-0.10520868*hcgs1_5+1.0161169*hcgs1_6+0.4738982*hcgs1_7+1.3726546*hcgs1_8+0.019165223*hcgs1_9+0.6629045*hcgs1_10+-0.17346822*hcgs1_11+-0.41499868*hcgs1_12+-0.2930857*hcgs1_13+-0.3305122*hcgs1_14+-0.82226783*hcgs1_15+0.01908325*hcgs1_16+0.019351097*hcgs1_17+0.09138516*hcgs1_18+-1.2453144*hcgs1_19+-0.88000125*hcgs1_20+0.48374525*hcgs1_21+-0.2261362*hcgs1_22+0.6680502*hcgs1_23+0.22479443*hcgs1_24+-0.056186553);
hcgs2_10 = tanh(0.0064860974*hcgs1_0+0.00648306*hcgs1_1+0.48692945*hcgs1_2+2.3550978*hcgs1_3+0.43859667*hcgs1_4+0.27351967*hcgs1_5+0.90961814*hcgs1_6+-0.017722035*hcgs1_7+0.5930781*hcgs1_8+0.0064157885*hcgs1_9+0.4308463*hcgs1_10+-0.28399688*hcgs1_11+0.30260938*hcgs1_12+-0.39435783*hcgs1_13+-0.1002725*hcgs1_14+-2.053321*hcgs1_15+0.006337951*hcgs1_16+0.006645003*hcgs1_17+-1.2891791*hcgs1_18+0.05721846*hcgs1_19+-0.37843162*hcgs1_20+0.5648725*hcgs1_21+-0.6181118*hcgs1_22+1.1590537*hcgs1_23+-2.7134886*hcgs1_24+0.54398286);
hcgs2_11 = tanh(0.14230382*hcgs1_0+0.123352334*hcgs1_1+0.042968668*hcgs1_2+0.047534492*hcgs1_3+0.010582293*hcgs1_4+-0.06643509*hcgs1_5+-0.13723876*hcgs1_6+-0.12684533*hcgs1_7+-0.040209897*hcgs1_8+0.13827254*hcgs1_9+-0.17713757*hcgs1_10+-0.35476053*hcgs1_11+-0.114496075*hcgs1_12+0.2810919*hcgs1_13+0.584066*hcgs1_14+0.017237866*hcgs1_15+0.14104304*hcgs1_16+0.13508707*hcgs1_17+-0.010557453*hcgs1_18+-0.1474484*hcgs1_19+-0.29602262*hcgs1_20+0.028033255*hcgs1_21+-0.22550379*hcgs1_22+-0.04313099*hcgs1_23+-0.11113166*hcgs1_24+-0.028289912);
y_cgs = -0.090056084*hcgs2_0+-0.31736207*hcgs2_1+-0.24686596*hcgs2_2+-0.14114563*hcgs2_3+-0.03698175*hcgs2_4+-0.20639718*hcgs2_5+0.0935527*hcgs2_6+-0.028302789*hcgs2_7+0.0030376983*hcgs2_8+0.07618971*hcgs2_9+0.121289134*hcgs2_10+-1.5651603e-05*hcgs2_11+0.0065943017;

h1_0 = tanh(1.3682936*Vgs+0.10864725*Vds+0.09570831*temp+-0.56370336);
h1_1 = tanh(0.35757086*Vgs+-0.3125519*Vds+-0.077800125*temp+0.06512575);
h1_2 = tanh(-3.467709*Vgs+0.1477079*Vds+-0.35400343*temp+0.56840074);
h1_3 = tanh(-0.41761824*Vgs+0.37827784*Vds+0.009629602*temp+-0.08403502);
h1_4 = tanh(0.077388346*Vgs+-0.13592862*Vds+-0.49125296*temp+-0.47875088);
h1_5 = tanh(1.7685989*Vgs+0.21931557*Vds+0.045224447*temp+-0.696139);
h1_6 = tanh(0.28883797*Vgs+2.7168286*Vds+-0.014564195*temp+0.035920236);
h1_7 = tanh(-0.28651348*Vgs+-9.313321*Vds+-0.018356342*temp+-0.085513815);
h1_8 = tanh(0.21481839*Vgs+0.48261166*Vds+-0.47899178*temp+0.02021197);
h1_9 = tanh(0.3764944*Vgs+-0.017693995*Vds+0.032974098*temp+-0.13071771);
h1_10 = tanh(1.6996965*Vgs+0.18676242*Vds+0.025404718*temp+-0.55340487);
h1_11 = tanh(-0.4527269*Vgs+12.459189*Vds+0.013352115*temp+0.3704853);
h1_12 = tanh(0.15709274*Vgs+0.42546245*Vds+0.039602395*temp+0.28179026);
h1_13 = tanh(0.55895686*Vgs+1.0040058*Vds+-0.05267897*temp+-0.29336983);
h1_14 = tanh(4.2247148*Vgs+-0.52595556*Vds+-0.12711817*temp+-0.5976594);
h1_15 = tanh(0.050546605*Vgs+-0.330268*Vds+-0.06530699*temp+0.090546615);
h1_16 = tanh(0.9399727*Vgs+0.0031915598*Vds+-1.8324652*temp+-0.2205463);
h1_17 = tanh(-0.36686787*Vgs+-0.11064151*Vds+-0.042833354*temp+-0.06403406);
h1_18 = tanh(-3.3207998*Vgs+-0.25093615*Vds+-0.14441161*temp+0.68027735);
h1_19 = tanh(0.22013985*Vgs+0.16096348*Vds+0.12568545*temp+-0.19767043);
h1_20 = tanh(-0.35515684*Vgs+0.053924657*Vds+-0.0077392324*temp+0.057896234);
h1_21 = tanh(-0.3571371*Vgs+0.30318564*Vds+0.14166854*temp+-0.0015784041);
h1_22 = tanh(-2.0759382*Vgs+0.21130794*Vds+-0.2811531*temp+0.59296787);
h1_23 = tanh(-1.8778507*Vgs+1.8716447*Vds+-0.009100372*temp+0.49192002);
h1_24 = tanh(0.30428374*Vgs+-0.015096752*Vds+-0.25874755*temp+-0.5299717);

h2_0 = tanh(-0.15121306*h1_0+0.13216132*h1_1+-0.06536988*h1_2+-0.07753303*h1_3+-0.0627017*h1_4+0.30817467*h1_5+0.11937187*h1_6+-0.09046796*h1_7+0.24907851*h1_8+-0.16025625*h1_9+-0.05446359*h1_10+-0.09405452*h1_11+0.34127882*h1_12+-0.28119335*h1_13+-0.021876749*h1_14+0.118707955*h1_15+-0.104816854*h1_16+0.25671437*h1_17+0.1401316*h1_18+-0.17812668*h1_19+0.13694039*h1_20+0.24994308*h1_21+-0.11344952*h1_22+-0.027708618*h1_23+0.21742071*h1_24+-0.076762326);
h2_1 = tanh(-0.78145427*h1_0+0.38053373*h1_1+0.63497144*h1_2+-0.55272585*h1_3+-0.373359*h1_4+-0.7319228*h1_5+-0.05778615*h1_6+-0.33025324*h1_7+0.109700605*h1_8+-0.33131123*h1_9+-0.8748794*h1_10+-0.79402417*h1_11+0.16941217*h1_12+-0.73933774*h1_13+-1.0077897*h1_14+0.39914912*h1_15+-0.06262417*h1_16+-0.187232*h1_17+0.74213463*h1_18+-0.48632947*h1_19+-0.09713008*h1_20+-0.034007765*h1_21+0.5337477*h1_22+-0.28644073*h1_23+-0.41770694*h1_24+0.3940315);
h2_2 = tanh(-0.14617051*h1_0+0.25919902*h1_1+-0.5032373*h1_2+-0.07702238*h1_3+0.3340654*h1_4+-0.37784195*h1_5+-0.32679927*h1_6+0.05280126*h1_7+-0.31073138*h1_8+-0.068601824*h1_9+0.255499*h1_10+-0.68618524*h1_11+0.009995105*h1_12+-0.23976146*h1_13+0.3596561*h1_14+0.27053067*h1_15+0.03925609*h1_16+0.014708283*h1_17+-0.50378793*h1_18+-0.325128*h1_19+0.056111608*h1_20+-0.3846926*h1_21+-0.31956074*h1_22+0.018524071*h1_23+0.2912199*h1_24+-0.17706223);
h2_3 = tanh(1.0192437*h1_0+0.2952312*h1_1+-0.7184485*h1_2+-0.15942204*h1_3+-0.22898962*h1_4+1.3602419*h1_5+0.4147001*h1_6+-0.32613468*h1_7+0.118665*h1_8+0.5156584*h1_9+1.6330078*h1_10+-0.18999998*h1_11+-0.24546975*h1_12+0.59235495*h1_13+-0.46896648*h1_14+0.011898787*h1_15+0.13594724*h1_16+-0.06423594*h1_17+-0.5831111*h1_18+0.26271695*h1_19+-0.27697167*h1_20+-0.5960629*h1_21+-0.47877562*h1_22+-0.2673843*h1_23+0.44113356*h1_24+0.15833028);
h2_4 = tanh(0.17485787*h1_0+-0.25197658*h1_1+0.28340328*h1_2+0.16298757*h1_3+0.46007058*h1_4+0.553364*h1_5+-0.16016534*h1_6+1.0048313*h1_7+-0.3832989*h1_8+0.09607217*h1_9+0.27223524*h1_10+-1.6277565*h1_11+-0.44554186*h1_12+-0.15214185*h1_13+-0.28318292*h1_14+-0.08641726*h1_15+-0.160874*h1_16+0.30158028*h1_17+0.3493247*h1_18+0.10298933*h1_19+0.31361485*h1_20+0.08613576*h1_21+0.061518542*h1_22+-0.16366996*h1_23+0.54973364*h1_24+-0.14373721);
h2_5 = tanh(0.33935156*h1_0+-0.08764859*h1_1+0.08953759*h1_2+-0.05985805*h1_3+0.05981396*h1_4+-0.011299745*h1_5+-0.02944149*h1_6+0.20493864*h1_7+-0.116612725*h1_8+-0.15411314*h1_9+-0.2864036*h1_10+0.15415801*h1_11+-0.021363351*h1_12+0.093431406*h1_13+-0.10056162*h1_14+0.16345838*h1_15+0.0015177551*h1_16+-0.17144275*h1_17+-0.32250997*h1_18+-0.40101108*h1_19+-0.24455239*h1_20+-0.030690923*h1_21+0.032743175*h1_22+0.09200769*h1_23+-0.009600082*h1_24+-0.017085247);
h2_6 = tanh(0.0015024132*h1_0+0.11969699*h1_1+0.059993733*h1_2+0.14998081*h1_3+-0.18102922*h1_4+-0.15189783*h1_5+-0.013850557*h1_6+0.052810382*h1_7+-0.038621705*h1_8+0.37050495*h1_9+0.12435658*h1_10+0.04176931*h1_11+0.25870085*h1_12+-0.17529541*h1_13+0.0032982996*h1_14+-0.020419518*h1_15+0.000102264756*h1_16+-0.047449198*h1_17+-0.081498176*h1_18+0.0023551183*h1_19+-0.29558685*h1_20+-0.31671983*h1_21+0.10424289*h1_22+0.12005399*h1_23+0.20814547*h1_24+-0.12134417);
h2_7 = tanh(0.3694447*h1_0+0.73069036*h1_1+0.27723643*h1_2+-0.4362233*h1_3+-0.3097266*h1_4+0.5422265*h1_5+0.3272098*h1_6+-0.25918573*h1_7+-0.24368867*h1_8+0.5618453*h1_9+0.5242211*h1_10+0.08813855*h1_11+0.6799796*h1_12+-0.3979165*h1_13+-0.1711708*h1_14+0.13701682*h1_15+-0.24496073*h1_16+-0.71914124*h1_17+-0.124262586*h1_18+0.084907345*h1_19+-0.81107986*h1_20+-0.042808235*h1_21+-0.25911286*h1_22+0.5207043*h1_23+-0.68941134*h1_24+0.62509125);
h2_8 = tanh(-0.23667358*h1_0+0.21428381*h1_1+-0.17944007*h1_2+-0.53466874*h1_3+-0.26333508*h1_4+-0.31620276*h1_5+-0.6176817*h1_6+0.94770783*h1_7+-0.59175736*h1_8+-0.08227842*h1_9+-0.266288*h1_10+-2.1777353*h1_11+-0.09606042*h1_12+-0.42297733*h1_13+0.5187814*h1_14+0.49746162*h1_15+0.05113266*h1_16+0.12460591*h1_17+-0.22088951*h1_18+-0.049250767*h1_19+-0.16544543*h1_20+-0.3502534*h1_21+0.099300504*h1_22+-0.21233742*h1_23+0.17207603*h1_24+0.1050419);
h2_9 = tanh(1.6620463*h1_0+0.32206154*h1_1+-3.1514213*h1_2+-0.32244164*h1_3+0.51665545*h1_4+2.200411*h1_5+0.18448223*h1_6+-0.091657795*h1_7+-0.11602166*h1_8+0.2834186*h1_9+1.9558989*h1_10+0.57678777*h1_11+0.13611092*h1_12+0.4963337*h1_13+1.5979456*h1_14+-0.06201662*h1_15+0.8314393*h1_16+0.059594274*h1_17+-1.8551767*h1_18+0.31630987*h1_19+-0.28522167*h1_20+-0.16381645*h1_21+-1.4269335*h1_22+-0.2152464*h1_23+0.029742906*h1_24+-0.07692551);
h2_10 = tanh(-0.6429212*h1_0+-0.16028342*h1_1+-0.14567703*h1_2+0.15797648*h1_3+-0.052756388*h1_4+-0.6921917*h1_5+-0.33475283*h1_6+0.015431626*h1_7+0.5116605*h1_8+-0.28691453*h1_9+-0.21460195*h1_10+-0.094519*h1_11+0.3061926*h1_12+-0.43866923*h1_13+0.16803505*h1_14+-0.1590696*h1_15+-0.07571661*h1_16+-0.0147782555*h1_17+0.15124124*h1_18+-0.4375861*h1_19+0.27025503*h1_20+-0.18030754*h1_21+0.33994296*h1_22+0.42213747*h1_23+-0.21455045*h1_24+0.16839875);
h2_11 = tanh(-1.2954369*h1_0+-0.12832154*h1_1+0.3837911*h1_2+0.28372845*h1_3+-0.27130753*h1_4+-1.3768084*h1_5+0.14717877*h1_6+-0.092729814*h1_7+0.3367126*h1_8+-0.24696465*h1_9+-1.0136137*h1_10+-0.004552687*h1_11+-0.28210768*h1_12+-0.4761171*h1_13+-0.90736765*h1_14+-0.056111965*h1_15+-0.2993499*h1_16+0.54925597*h1_17+0.72715276*h1_18+-0.114946246*h1_19+0.44456843*h1_20+0.46368077*h1_21+0.9335892*h1_22+0.55129546*h1_23+0.15040335*h1_24+-0.046020713);
h2_12 = tanh(-0.22911856*h1_0+-0.43084428*h1_1+-0.5708865*h1_2+-0.014085635*h1_3+-0.031142928*h1_4+-0.42261887*h1_5+-0.79023165*h1_6+1.7135651*h1_7+-0.15990627*h1_8+-0.3152476*h1_9+-0.3980455*h1_10+-3.227983*h1_11+-0.5061344*h1_12+-0.26970962*h1_13+0.5441539*h1_14+0.1418216*h1_15+0.03443026*h1_16+0.442166*h1_17+-0.541745*h1_18+0.004449378*h1_19+0.010362773*h1_20+-0.04998462*h1_21+-0.3069243*h1_22+-0.46285695*h1_23+-0.1416931*h1_24+-0.012346868);
h2_13 = tanh(-1.8857709*h1_0+-0.49025315*h1_1+2.9024224*h1_2+0.4528477*h1_3+-0.29217008*h1_4+-1.8506876*h1_5+-0.32379347*h1_6+0.31577328*h1_7+-0.2879506*h1_8+-0.4468048*h1_9+-2.3214548*h1_10+-0.402881*h1_11+-0.02285734*h1_12+-0.5379914*h1_13+-1.4103202*h1_14+0.04002565*h1_15+-0.81248933*h1_16+0.16944006*h1_17+2.2094445*h1_18+-0.334258*h1_19+0.5090875*h1_20+0.36438248*h1_21+1.762124*h1_22+0.57309586*h1_23+0.1488414*h1_24+-0.14031138);
h2_14 = tanh(0.0392183*h1_0+-0.11461049*h1_1+0.08622911*h1_2+0.16133071*h1_3+0.35466343*h1_4+0.15916745*h1_5+-0.34902015*h1_6+-0.014009927*h1_7+-0.15942396*h1_8+0.20350459*h1_9+-0.43946564*h1_10+-0.64061844*h1_11+-0.12759931*h1_12+-0.30195904*h1_13+0.26310438*h1_14+-0.038219254*h1_15+0.3304054*h1_16+0.14586565*h1_17+0.08333233*h1_18+0.17872004*h1_19+-0.0031158226*h1_20+0.30691078*h1_21+0.19418429*h1_22+0.50309086*h1_23+0.35537028*h1_24+-0.3887699);
y = -0.003547749*h2_0+-0.33443508*h2_1+-0.19703725*h2_2+-0.28773198*h2_3+-0.49190745*h2_4+0.00024956328*h2_5+0.0017673661*h2_6+-0.50377244*h2_7+0.18774104*h2_8+0.6415266*h2_9+-0.074222274*h2_10+-0.26616418*h2_11+-0.25925675*h2_12+0.49704534*h2_13+-0.35092828*h2_14+-0.05331843;

Cgd = pow(10, (y_cgd/normO_cgd + MinO_cgd))*W/15; //traning width was 15um
Cgs = pow(10, (y_cgs/normO_cgs + MinO_cgs))*W/15;
Cgg = Cgd+Cgs;

Id = pow(10, (y/normI + MinI))*W*3;
I(g, d) <+ Cgd*ddt(Vg-Vd) ;
I(g, s) <+ Cgs*ddt(Vg-Vs) ;

if (Vd >= Vs) begin
	I(d, s) <+ dir*Id;
end

else begin
	I(d, s) <+ dir*Id;
end

end
endmodule
