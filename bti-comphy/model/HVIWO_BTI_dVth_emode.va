// VerilogA for ML_HV, ML_HV_emode, veriloga

`include "constants.vams"
`include "disciplines.vams"

module ML_HV_emode_rev3(d, g, s);

inout d, g, s;
electrical d, g, s;

//****** Parameters L and W ********
parameter real W = 3;
parameter real L = 0.6;
parameter MinVg = -6.0 ;
parameter normVg = 0.05555555555555555 ;
parameter MinVd = 0.0 ;
parameter normVd = 0.08333333333333333 ;
parameter MinLg = 0 ;
parameter normLg = 1.66666667 ;
parameter MinI = -14.614393726401689 ;
parameter normI = 0.0975145951626748;
parameter vth =0;
parameter real T_stress = 1; //set on cadence as variable
parameter real Temp = 25; //set on cadence as variable

parameter MinVg_cgs = -6.0 ;
parameter normVg_cgs = 0.05555555555555555 ;
parameter MinVd_cgs = -6.0 ;
parameter normVd_cgs = 0.05555555555555555 ;
parameter MinLg_cgs = 0.6 ;
parameter normLg_cgs = 0 ;
parameter MinO_cgs = -13.164309428507574 ;
parameter normO_cgs =2.3582977043250914;

parameter MinVg_cgd = -6.0 ;
parameter normVg_cgd = 0.05555555555555555 ;
parameter MinVd_cgd = -4.0 ;
parameter normVd_cgd = 0.06349206349206349 ;
parameter MinLg_cgd = 0.6 ;
parameter normLg_cgd = 0 ;
parameter MinO_cgd = -14.010995384301463 ;
parameter normO_cgd =1.5234203322209112;

parameter Mint_stress = 1.0 ;
parameter normt_stress = 0.001001001001001001 ;
parameter Mintemperature = 25 ;
parameter normtemperature = 0.016666666666666666 ;
parameter Mindelta_Vth = 0.00614 ;
parameter normdelta_Vth = 0.021388891 ;

real hvth1_0, hvth1_1, hvth1_2, hvth1_3, hvth1_4, hvth1_5, hvth1_6, hvth1_7, hvth1_8, hvth1_9, hvth1_10, hvth1_11, hvth1_12, hvth1_13, hvth1_14, hvth1_15;
real hvth2_0, hvth2_1, hvth2_2, hvth2_3, hvth2_4, hvth2_5, hvth2_6, hvth2_7;

real Vg, Vd, Vs, Vgs, Vds, Lg, Id, Cgg, Cgs,Cgd, Vgd;
real y, y_cgg, y_cgs, y_cgd, yvth;
real Vgs_cgg, Vgs_cgs, Vgs_cgd;
real Vds_cgg, Vds_cgs, Vds_cgd;
real Lg_cgg, Lg_cgs, Lg_cgd;
real Vgsraw, Vgdraw, dir;
real Vdi, Vsi;
real t_stress, v_ov, t_rec, clk_loops, temp, delta_Vth;

real h1_0, h1_1, h1_2, h1_3, h1_4, h1_5, h1_6, h1_7, h1_8, h1_9, h1_10, h1_11, h1_12, h1_13, h1_14, h1_15, h1_16, h1_17, h1_18, h1_19, h1_20, h1_21, h1_22, h1_23, h1_24;
real h2_0, h2_1, h2_2, h2_3, h2_4, h2_5, h2_6, h2_7, h2_8, h2_9, h2_10, h2_11;
real hcgg1_0, hcgg1_1, hcgg1_2, hcgg1_3, hcgg1_4, hcgg1_5, hcgg1_6, hcgg1_7, hcgg1_8, hcgg1_9, hcgg1_10, hcgg1_11, hcgg1_12, hcgg1_13, hcgg1_14, hcgg1_15, hcgg1_16, hcgg1_17, hcgg1_18, hcgg1_19, hcgg1_20, hcgg1_21, hcgg1_22, hcgg1_23, hcgg1_24;
real hcgg2_0, hcgg2_1, hcgg2_2, hcgg2_3, hcgg2_4, hcgg2_5, hcgg2_6, hcgg2_7, hcgg2_8, hcgg2_9, hcgg2_10, hcgg2_11;
real hcgs1_0, hcgs1_1, hcgs1_2, hcgs1_3, hcgs1_4, hcgs1_5, hcgs1_6, hcgs1_7, hcgs1_8, hcgs1_9, hcgs1_10, hcgs1_11, hcgs1_12, hcgs1_13, hcgs1_14, hcgs1_15, hcgs1_16, hcgs1_17, hcgs1_18, hcgs1_19, hcgs1_20, hcgs1_21, hcgs1_22, hcgs1_23, hcgs1_24;
real hcgs2_0, hcgs2_1, hcgs2_2, hcgs2_3, hcgs2_4, hcgs2_5, hcgs2_6, hcgs2_7, hcgs2_8, hcgs2_9, hcgs2_10, hcgs2_11;
real hcgd1_0, hcgd1_1, hcgd1_2, hcgd1_3, hcgd1_4, hcgd1_5, hcgd1_6, hcgd1_7, hcgd1_8, hcgd1_9, hcgd1_10, hcgd1_11, hcgd1_12, hcgd1_13, hcgd1_14, hcgd1_15, hcgd1_16, hcgd1_17, hcgd1_18, hcgd1_19, hcgd1_20, hcgd1_21, hcgd1_22, hcgd1_23, hcgd1_24;
real hcgd2_0, hcgd2_1, hcgd2_2, hcgd2_3, hcgd2_4, hcgd2_5, hcgd2_6, hcgd2_7, hcgd2_8, hcgd2_9, hcgd2_10, hcgd2_11;

real Qgd, Qgs;

analog begin

temp = (Temp - Mintemperature)*normtemperature;
t_stress = (T_stress - Mint_stress)*normt_stress;

//******************** delta_Vth NN **********************************//

hvth1_0 = tanh(4.4002986*t_stress+0.13983922*temp+0.0095059415);
hvth1_1 = tanh(-0.731448*t_stress+0.14707367*temp+-0.23541754);
hvth1_2 = tanh(0.18999684*t_stress+0.120208435*temp+-0.09435243);
hvth1_3 = tanh(3.3266392*t_stress+-0.1338074*temp+0.0023328918);
hvth1_4 = tanh(-0.7420221*t_stress+-0.26855975*temp+-0.095105216);
hvth1_5 = tanh(-0.40053654*t_stress+0.25632176*temp+0.06787888);
hvth1_6 = tanh(0.5816374*t_stress+-0.23239218*temp+0.02243891);
hvth1_7 = tanh(0.36332148*t_stress+-0.06948452*temp+-0.004198026);
hvth1_8 = tanh(0.6795921*t_stress+-0.32956377*temp+0.18402661);
hvth1_9 = tanh(0.45967075*t_stress+-0.30783534*temp+0.013147709);
hvth1_10 = tanh(0.10367114*t_stress+-0.10897806*temp+0.012378313);
hvth1_11 = tanh(0.5241847*t_stress+0.22551975*temp+-0.008120251);
hvth1_12 = tanh(-1.3924043*t_stress+0.02966609*temp+-0.04992909);
hvth1_13 = tanh(-0.1829997*t_stress+0.30073678*temp+0.015427229);
hvth1_14 = tanh(-0.8810281*t_stress+-0.73506755*temp+-0.034594454);
hvth1_15 = tanh(-2.0657573*t_stress+0.05542216*temp+-0.036831368);

hvth2_0 = tanh(0.14449877*hvth1_0+0.3203474*hvth1_1+-0.32588643*hvth1_2+0.45089495*hvth1_3+0.47596216*hvth1_4+-0.35819858*hvth1_5+0.2326565*hvth1_6+-0.36326265*hvth1_7+-0.48811617*hvth1_8+-0.30419973*hvth1_9+0.33879533*hvth1_10+-0.03204754*hvth1_11+0.42893898*hvth1_12+-0.2426072*hvth1_13+0.020931425*hvth1_14+-0.009312627*hvth1_15+-0.07166866);
hvth2_1 = tanh(0.13595577*hvth1_0+0.16891788*hvth1_1+-0.49537298*hvth1_2+0.08869149*hvth1_3+-0.18422693*hvth1_4+-0.11253915*hvth1_5+0.0444903*hvth1_6+-0.28849855*hvth1_7+0.2552169*hvth1_8+-0.5797979*hvth1_9+0.23429447*hvth1_10+-0.34624717*hvth1_11+0.4789288*hvth1_12+0.2960094*hvth1_13+-0.026964663*hvth1_14+-0.19546272*hvth1_15+0.051302083);
hvth2_2 = tanh(0.4781589*hvth1_0+-0.39161503*hvth1_1+-0.26649016*hvth1_2+-0.61682725*hvth1_3+-0.23353283*hvth1_4+-0.10713724*hvth1_5+-0.2666957*hvth1_6+-0.15914343*hvth1_7+0.11189942*hvth1_8+-0.35434946*hvth1_9+0.4025544*hvth1_10+-0.26625735*hvth1_11+0.10293101*hvth1_12+-0.10723214*hvth1_13+0.25552425*hvth1_14+-0.109538235*hvth1_15+0.06242121);
hvth2_3 = tanh(-0.25318062*hvth1_0+0.373996*hvth1_1+0.21388936*hvth1_2+-0.36720476*hvth1_3+-0.4728468*hvth1_4+0.5544033*hvth1_5+-0.059715677*hvth1_6+0.16308662*hvth1_7+-0.7545961*hvth1_8+-0.12749965*hvth1_9+-0.20710278*hvth1_10+0.34646377*hvth1_11+0.04571012*hvth1_12+0.12754895*hvth1_13+0.26191953*hvth1_14+0.025788136*hvth1_15+0.0020722284);
hvth2_4 = tanh(-0.09721173*hvth1_0+-0.24874628*hvth1_1+0.38726363*hvth1_2+-0.050579343*hvth1_3+0.08149567*hvth1_4+0.3621912*hvth1_5+0.4242709*hvth1_6+0.32088947*hvth1_7+0.3525533*hvth1_8+-0.21818145*hvth1_9+-0.1545736*hvth1_10+0.206645*hvth1_11+-0.3135045*hvth1_12+-0.33971882*hvth1_13+0.10592691*hvth1_14+0.14754814*hvth1_15+0.11487955);
hvth2_5 = tanh(-0.26740152*hvth1_0+-0.6982515*hvth1_1+-0.08474242*hvth1_2+0.019018041*hvth1_3+-0.3589899*hvth1_4+-0.0973528*hvth1_5+0.11607169*hvth1_6+0.19930331*hvth1_7+0.36271593*hvth1_8+-0.26375148*hvth1_9+-0.015975302*hvth1_10+0.29052237*hvth1_11+-0.47726715*hvth1_12+0.23121832*hvth1_13+0.27116385*hvth1_14+0.261655*hvth1_15+0.04005981);
hvth2_6 = tanh(-0.05076342*hvth1_0+0.10022507*hvth1_1+0.0138145285*hvth1_2+-0.081644274*hvth1_3+-0.1592732*hvth1_4+0.11312352*hvth1_5+-0.34587634*hvth1_6+0.19398122*hvth1_7+-0.22699691*hvth1_8+-0.52661735*hvth1_9+-0.29047686*hvth1_10+-0.572356*hvth1_11+0.3649812*hvth1_12+0.4685821*hvth1_13+0.26052803*hvth1_14+0.0049602045*hvth1_15+0.0067401035);
hvth2_7 = tanh(-2.302981*hvth1_0+0.88205665*hvth1_1+-0.014244103*hvth1_2+-2.7229753*hvth1_3+0.8704846*hvth1_4+0.20269625*hvth1_5+-0.5046953*hvth1_6+-0.23645547*hvth1_7+-0.9837086*hvth1_8+-0.3482821*hvth1_9+-0.20679511*hvth1_10+-0.60126776*hvth1_11+1.4770023*hvth1_12+0.060563616*hvth1_13+1.0323116*hvth1_14+2.2257605*hvth1_15+-0.050422482);

yvth = 0.4027771*hvth2_0+-0.6521628*hvth2_1+-0.36696523*hvth2_2+0.23569995*hvth2_3+-0.7517589*hvth2_4+0.17004673*hvth2_5+-0.60027295*hvth2_6+-0.93044275*hvth2_7+-0.069171295;

delta_Vth = (yvth - Mindelta_Vth) * normdelta_Vth;
$strobe("dvth=$g",delta_Vth);

	Vg = V(g);
	Vs = V(s);
	Vd = V(d);
    Vgsraw = Vg-Vs ;
    Vgdraw = Vg-Vd ;
if (Vgsraw>=Vgdraw) begin
	Vgs = ((Vg-Vs) - MinVg - vth - delta_Vth) * normVg ;

	Vgs_cgs = ((Vg-Vs) - MinVg_cgs - vth - delta_Vth) * normVg_cgs ;
	Vgs_cgd = ((Vg-Vs) - MinVg_cgd - vth - delta_Vth) * normVg_cgd ;
	dir = 1 ;
end
else begin
	Vgs = ((Vg-Vd) - MinVg - vth) * normVg ;

	Vgs_cgs = ((Vg-Vd) - MinVg_cgs - vth - delta_Vth) * normVg_cgs ;
	Vgs_cgd = ((Vg-Vd) - MinVg_cgd - vth - delta_Vth) * normVg_cgd ;
	dir = -1 ;
end

	Vds = (abs(Vd-Vs) - MinVd) * normVd ;

	Vds_cgs = (abs(Vd-Vs) - MinVd_cgs) * normVd_cgs ;
	Vds_cgd = (abs(Vd-Vs) - MinVd_cgd) * normVd_cgd ;

	Lg = (L -MinLg)*normLg ;

	Lg_cgs = (L -MinLg_cgs)*normLg_cgs ;
	Lg_cgd = (L -MinLg_cgd)*normLg_cgd ;

hcgd1_0 = tanh(-0.073090345*Vgs_cgd+1.7493699*Vds_cgd+-0.25351274*Lg_cgd+-0.30203047);
hcgd1_1 = tanh(-0.81192595*Vgs_cgd+0.7702285*Vds_cgd+0.32290834*Lg_cgd+0.12260828);
hcgd1_2 = tanh(-1.4992723*Vgs_cgd+1.0054874*Vds_cgd+-0.040279582*Lg_cgd+0.23167521);
hcgd1_3 = tanh(-0.27198792*Vgs_cgd+0.14240761*Vds_cgd+-0.45070043*Lg_cgd+-0.47009295);
hcgd1_4 = tanh(0.5909458*Vgs_cgd+0.1271886*Vds_cgd+0.25604323*Lg_cgd+-0.3614964);
hcgd1_5 = tanh(1.1455232*Vgs_cgd+-0.1336111*Vds_cgd+0.16404216*Lg_cgd+-0.3844855);
hcgd1_6 = tanh(0.14468843*Vgs_cgd+2.6229973*Vds_cgd+-0.39613384*Lg_cgd+0.23941508);
hcgd1_7 = tanh(-0.20886186*Vgs_cgd+3.2628205*Vds_cgd+0.132442*Lg_cgd+-0.49246147);
hcgd1_8 = tanh(0.48230776*Vgs_cgd+0.20745495*Vds_cgd+0.17956811*Lg_cgd+0.13416706);
hcgd1_9 = tanh(0.11828926*Vgs_cgd+-0.36482674*Vds_cgd+0.38881582*Lg_cgd+0.090164326);
hcgd1_10 = tanh(0.013121906*Vgs_cgd+2.042608*Vds_cgd+0.15619394*Lg_cgd+-0.17228433);
hcgd1_11 = tanh(0.85692364*Vgs_cgd+1.0132248*Vds_cgd+0.20936537*Lg_cgd+-1.0232097);
hcgd1_12 = tanh(-0.07165884*Vgs_cgd+-0.3623631*Vds_cgd+0.14471789*Lg_cgd+0.55825126);
hcgd1_13 = tanh(-0.45831093*Vgs_cgd+-0.27587467*Vds_cgd+0.087761946*Lg_cgd+0.24322145);
hcgd1_14 = tanh(-0.12094344*Vgs_cgd+-1.3313415*Vds_cgd+0.3058515*Lg_cgd+0.38591075);
hcgd1_15 = tanh(-0.48209256*Vgs_cgd+4.390121*Vds_cgd+-0.22924025*Lg_cgd+-0.22238722);
hcgd1_16 = tanh(-0.13342527*Vgs_cgd+-0.17032403*Vds_cgd+-0.19245708*Lg_cgd+-0.34511408);
hcgd1_17 = tanh(-0.019135991*Vgs_cgd+1.6390436*Vds_cgd+-0.39458174*Lg_cgd+-0.374234);
hcgd1_18 = tanh(1.9993974*Vgs_cgd+-0.6025967*Vds_cgd+0.051945195*Lg_cgd+-0.2606078);
hcgd1_19 = tanh(-1.319852*Vgs_cgd+-1.4124283*Vds_cgd+-0.16422051*Lg_cgd+0.60615516);
hcgd1_20 = tanh(0.7590748*Vgs_cgd+0.35662842*Vds_cgd+-0.32554984*Lg_cgd+-0.45226586);
hcgd1_21 = tanh(-0.0644961*Vgs_cgd+-1.4253865*Vds_cgd+0.31603792*Lg_cgd+0.34580982);
hcgd1_22 = tanh(-0.024503596*Vgs_cgd+-1.2409326*Vds_cgd+0.266246*Lg_cgd+0.05068574);
hcgd1_23 = tanh(0.40497908*Vgs_cgd+-0.5119794*Vds_cgd+0.27652997*Lg_cgd+-0.49364495);
hcgd1_24 = tanh(-0.66816944*Vgs_cgd+0.23831755*Vds_cgd+0.3236202*Lg_cgd+0.45229998);
hcgd2_0 = tanh(-0.8581911*hcgd1_0+-1.7806648*hcgd1_1+-2.3480477*hcgd1_2+-0.060092464*hcgd1_3+1.0001435*hcgd1_4+1.0480509*hcgd1_5+-0.3004585*hcgd1_6+-0.98489136*hcgd1_7+0.15593737*hcgd1_8+0.70743585*hcgd1_9+-0.24457291*hcgd1_10+0.9940044*hcgd1_11+0.23668307*hcgd1_12+-0.5144086*hcgd1_13+0.16627982*hcgd1_14+-1.4144597*hcgd1_15+-0.11155476*hcgd1_16+-0.3225649*hcgd1_17+1.4172044*hcgd1_18+0.61510265*hcgd1_19+0.8610263*hcgd1_20+-0.044497408*hcgd1_21+0.46571997*hcgd1_22+-0.013894911*hcgd1_23+-1.1907585*hcgd1_24+0.14715073);
hcgd2_1 = tanh(0.74444413*hcgd1_0+0.60665065*hcgd1_1+0.396881*hcgd1_2+-0.0940794*hcgd1_3+-0.27899864*hcgd1_4+-0.087556325*hcgd1_5+0.40643474*hcgd1_6+1.366464*hcgd1_7+-0.17410953*hcgd1_8+-0.012924953*hcgd1_9+0.56350505*hcgd1_10+0.36612725*hcgd1_11+-0.26115453*hcgd1_12+-0.29767877*hcgd1_13+-0.4200406*hcgd1_14+1.1142844*hcgd1_15+0.19850636*hcgd1_16+0.8344988*hcgd1_17+0.11088754*hcgd1_18+-0.26612458*hcgd1_19+-0.27794132*hcgd1_20+-0.80967337*hcgd1_21+-0.11269937*hcgd1_22+-0.23162273*hcgd1_23+-0.098596975*hcgd1_24+0.09286805);
hcgd2_2 = tanh(-0.7313956*hcgd1_0+-0.7514108*hcgd1_1+-0.5736202*hcgd1_2+-0.49893183*hcgd1_3+0.1765418*hcgd1_4+0.14255758*hcgd1_5+0.07957998*hcgd1_6+-0.66936827*hcgd1_7+0.2132876*hcgd1_8+0.13260117*hcgd1_9+-0.22507648*hcgd1_10+0.069224365*hcgd1_11+-0.031068536*hcgd1_12+0.0057172063*hcgd1_13+0.9005941*hcgd1_14+0.045649208*hcgd1_15+-0.4302063*hcgd1_16+-1.064374*hcgd1_17+0.100322045*hcgd1_18+0.1628234*hcgd1_19+-0.17792495*hcgd1_20+0.73057646*hcgd1_21+-0.04239934*hcgd1_22+0.07292476*hcgd1_23+-0.03253051*hcgd1_24+-0.069609255);
hcgd2_3 = tanh(0.14440651*hcgd1_0+0.3216678*hcgd1_1+0.51213056*hcgd1_2+0.42667162*hcgd1_3+-0.610052*hcgd1_4+-0.54205084*hcgd1_5+0.060548224*hcgd1_6+0.49424285*hcgd1_7+-0.5282787*hcgd1_8+0.046284102*hcgd1_9+-0.0018920621*hcgd1_10+-0.4451091*hcgd1_11+0.04757394*hcgd1_12+0.5863736*hcgd1_13+0.15133414*hcgd1_14+0.3255952*hcgd1_15+0.27865914*hcgd1_16+0.42173597*hcgd1_17+-0.6422138*hcgd1_18+0.1657985*hcgd1_19+-1.5046545*hcgd1_20+0.5070087*hcgd1_21+0.18432228*hcgd1_22+0.14772636*hcgd1_23+-0.35788894*hcgd1_24+-0.31562403);
hcgd2_4 = tanh(0.70184183*hcgd1_0+0.5248185*hcgd1_1+0.21824042*hcgd1_2+-0.1301908*hcgd1_3+0.29407513*hcgd1_4+0.17626354*hcgd1_5+1.0718364*hcgd1_6+1.0510215*hcgd1_7+0.696749*hcgd1_8+0.29669785*hcgd1_9+2.1009989*hcgd1_10+0.6151884*hcgd1_11+0.48851284*hcgd1_12+-0.56238925*hcgd1_13+-0.47341812*hcgd1_14+1.2261282*hcgd1_15+-0.35043222*hcgd1_16+0.12345494*hcgd1_17+0.106367536*hcgd1_18+-1.5799632*hcgd1_19+0.70326567*hcgd1_20+-1.4121299*hcgd1_21+-2.5126958*hcgd1_22+-0.34464827*hcgd1_23+0.2420689*hcgd1_24+0.3827352);
hcgd2_5 = tanh(0.07186469*hcgd1_0+-0.3057672*hcgd1_1+0.18167095*hcgd1_2+0.24679431*hcgd1_3+0.2861313*hcgd1_4+0.20745918*hcgd1_5+0.28961903*hcgd1_6+0.4754423*hcgd1_7+0.10851595*hcgd1_8+-0.57396716*hcgd1_9+0.19753388*hcgd1_10+0.25443172*hcgd1_11+-0.058893647*hcgd1_12+0.4978357*hcgd1_13+0.40544015*hcgd1_14+0.19733265*hcgd1_15+0.024174226*hcgd1_16+0.09329063*hcgd1_17+0.12140121*hcgd1_18+0.6866702*hcgd1_19+-0.090300076*hcgd1_20+0.4295404*hcgd1_21+0.21769053*hcgd1_22+0.06967293*hcgd1_23+0.13865103*hcgd1_24+0.0039349254);
hcgd2_6 = tanh(-0.13215303*hcgd1_0+-0.25777414*hcgd1_1+-0.24420205*hcgd1_2+0.15015651*hcgd1_3+0.7435888*hcgd1_4+0.5808469*hcgd1_5+0.23431543*hcgd1_6+-0.17212716*hcgd1_7+-0.08636741*hcgd1_8+-0.16209634*hcgd1_9+-0.24451429*hcgd1_10+0.64819676*hcgd1_11+-0.401811*hcgd1_12+-0.041673224*hcgd1_13+-0.1843273*hcgd1_14+-0.03913859*hcgd1_15+0.4648355*hcgd1_16+0.33676878*hcgd1_17+0.16188923*hcgd1_18+0.09970059*hcgd1_19+0.26570147*hcgd1_20+-0.34857365*hcgd1_21+-0.20715532*hcgd1_22+0.45225534*hcgd1_23+-0.67448044*hcgd1_24+-0.20020215);
hcgd2_7 = tanh(0.5814423*hcgd1_0+0.30674064*hcgd1_1+0.41730982*hcgd1_2+0.1271082*hcgd1_3+0.46041217*hcgd1_4+-0.14026274*hcgd1_5+0.38002715*hcgd1_6+0.15430027*hcgd1_7+0.37405762*hcgd1_8+-0.27523136*hcgd1_9+0.5767433*hcgd1_10+0.75470895*hcgd1_11+0.39034903*hcgd1_12+-0.08490812*hcgd1_13+-0.46258885*hcgd1_14+0.52702457*hcgd1_15+-0.36667594*hcgd1_16+-0.008625877*hcgd1_17+0.09137123*hcgd1_18+-0.7821849*hcgd1_19+0.70662326*hcgd1_20+-0.20326899*hcgd1_21+-0.11657497*hcgd1_22+-0.22169054*hcgd1_23+0.23076789*hcgd1_24+0.1994013);
hcgd2_8 = tanh(-7.4423213*hcgd1_0+-1.7918187*hcgd1_1+-2.273679*hcgd1_2+-0.35889605*hcgd1_3+-0.252701*hcgd1_4+0.9470301*hcgd1_5+-0.41792682*hcgd1_6+-7.6462445*hcgd1_7+0.018614734*hcgd1_8+1.2025093*hcgd1_9+-4.4235744*hcgd1_10+-1.8856794*hcgd1_11+0.31407484*hcgd1_12+0.08381061*hcgd1_13+2.0082252*hcgd1_14+-4.4953437*hcgd1_15+0.18078373*hcgd1_16+-2.2936556*hcgd1_17+2.0334883*hcgd1_18+-0.34214598*hcgd1_19+-0.29436678*hcgd1_20+4.8436127*hcgd1_21+1.8703012*hcgd1_22+0.32469234*hcgd1_23+-0.12540866*hcgd1_24+0.1331769);
hcgd2_9 = tanh(-0.008969171*hcgd1_0+0.25442964*hcgd1_1+0.33559665*hcgd1_2+0.059060458*hcgd1_3+-0.6700384*hcgd1_4+-0.595369*hcgd1_5+0.432537*hcgd1_6+0.48487276*hcgd1_7+-0.014844808*hcgd1_8+-0.029969316*hcgd1_9+0.4608879*hcgd1_10+-0.67345583*hcgd1_11+0.10385167*hcgd1_12+0.47509405*hcgd1_13+0.057980414*hcgd1_14+0.57206994*hcgd1_15+-0.083018914*hcgd1_16+0.24574327*hcgd1_17+-0.76715064*hcgd1_18+0.2543998*hcgd1_19+-0.210734*hcgd1_20+-0.17915764*hcgd1_21+-0.17944436*hcgd1_22+-0.17101662*hcgd1_23+0.27301717*hcgd1_24+-0.020215586);
hcgd2_10 = tanh(0.047154456*hcgd1_0+0.177622*hcgd1_1+-0.35302344*hcgd1_2+0.3784709*hcgd1_3+-0.21668567*hcgd1_4+-0.20013903*hcgd1_5+-0.4485513*hcgd1_6+-0.5680783*hcgd1_7+-0.25446296*hcgd1_8+0.0111656105*hcgd1_9+-0.4455899*hcgd1_10+-0.20770787*hcgd1_11+-0.27411363*hcgd1_12+0.6049824*hcgd1_13+0.13715369*hcgd1_14+-0.5386368*hcgd1_15+0.46778303*hcgd1_16+-0.21815602*hcgd1_17+0.47233215*hcgd1_18+0.5560222*hcgd1_19+-0.30228803*hcgd1_20+-0.057146665*hcgd1_21+0.446087*hcgd1_22+0.40810114*hcgd1_23+0.44648725*hcgd1_24+-0.06979678);
hcgd2_11 = tanh(0.52387154*hcgd1_0+-0.48277956*hcgd1_1+-0.7682235*hcgd1_2+-0.190172*hcgd1_3+1.175332*hcgd1_4+1.1926033*hcgd1_5+-0.36767244*hcgd1_6+0.3228836*hcgd1_7+0.295783*hcgd1_8+-0.20389546*hcgd1_9+0.11585899*hcgd1_10+1.6549429*hcgd1_11+-0.3883799*hcgd1_12+-0.54141515*hcgd1_13+-0.30675817*hcgd1_14+-0.34997156*hcgd1_15+0.2086648*hcgd1_16+0.36170647*hcgd1_17+1.6473606*hcgd1_18+-0.4781146*hcgd1_19+1.5642655*hcgd1_20+-0.7633239*hcgd1_21+-0.47981572*hcgd1_22+0.41335562*hcgd1_23+-0.3726435*hcgd1_24+-0.0653709);
y_cgd = -0.30169475*hcgd2_0+0.7017093*hcgd2_1+-0.18068637*hcgd2_2+-0.6699334*hcgd2_3+0.53903127*hcgd2_4+0.16665317*hcgd2_5+-0.3536876*hcgd2_6+-0.36382276*hcgd2_7+0.6040847*hcgd2_8+-0.43945295*hcgd2_9+0.5195485*hcgd2_10+-0.3194021*hcgd2_11+0.21705215;

hcgs1_0 = tanh(-0.9447249*Vgs_cgs+3.848607*Vds_cgs+-0.019748846*Lg_cgs+-1.5617282);
hcgs1_1 = tanh(-0.029012304*Vgs_cgs+-1.5533222*Vds_cgs+0.44389084*Lg_cgs+1.2160019);
hcgs1_2 = tanh(0.8694287*Vgs_cgs+-0.03134334*Vds_cgs+-0.052811515*Lg_cgs+-0.4674938);
hcgs1_3 = tanh(0.11125248*Vgs_cgs+-0.08053268*Vds_cgs+-0.14715484*Lg_cgs+0.2079814);
hcgs1_4 = tanh(0.9503431*Vgs_cgs+1.2066041*Vds_cgs+0.07638908*Lg_cgs+-1.5212817);
hcgs1_5 = tanh(1.2675861*Vgs_cgs+-0.20858626*Vds_cgs+-0.40374485*Lg_cgs+-0.6321944);
hcgs1_6 = tanh(0.32068986*Vgs_cgs+-0.55139714*Vds_cgs+0.29643092*Lg_cgs+0.09015624);
hcgs1_7 = tanh(-3.6914701*Vgs_cgs+0.6843926*Vds_cgs+0.14611645*Lg_cgs+1.1698359);
hcgs1_8 = tanh(-0.51712066*Vgs_cgs+0.8325061*Vds_cgs+0.2879668*Lg_cgs+-0.07329451);
hcgs1_9 = tanh(1.7683635*Vgs_cgs+-0.3458703*Vds_cgs+-0.16947505*Lg_cgs+-0.80866075);
hcgs1_10 = tanh(0.010235257*Vgs_cgs+-0.009958806*Vds_cgs+-0.046799034*Lg_cgs+0.0067180935);
hcgs1_11 = tanh(-0.56219107*Vgs_cgs+0.14688006*Vds_cgs+0.20843746*Lg_cgs+0.26059148);
hcgs1_12 = tanh(-0.07906894*Vgs_cgs+-0.10666679*Vds_cgs+-0.27857378*Lg_cgs+0.30169338);
hcgs1_13 = tanh(-1.6767093*Vgs_cgs+0.5625225*Vds_cgs+0.15607017*Lg_cgs+0.7490984);
hcgs1_14 = tanh(0.004656209*Vgs_cgs+-0.0067486507*Vds_cgs+-0.4438495*Lg_cgs+-0.00023583561);
hcgs1_15 = tanh(-0.87449557*Vgs_cgs+3.5775394*Vds_cgs+0.058419783*Lg_cgs+1.0822651);
hcgs1_16 = tanh(2.652287*Vgs_cgs+-2.3323097*Vds_cgs+-0.3422341*Lg_cgs+0.3537005);
hcgs1_17 = tanh(0.88335234*Vgs_cgs+-0.3338322*Vds_cgs+-0.11836058*Lg_cgs+-0.40532526);
hcgs1_18 = tanh(-0.6324544*Vgs_cgs+5.362017*Vds_cgs+0.20589639*Lg_cgs+-1.5765152);
hcgs1_19 = tanh(0.52068394*Vgs_cgs+-1.1275563*Vds_cgs+0.19503203*Lg_cgs+0.16029519);
hcgs1_20 = tanh(-1.3330969*Vgs_cgs+0.12449422*Vds_cgs+-0.0033548062*Lg_cgs+0.709236);
hcgs1_21 = tanh(0.19407558*Vgs_cgs+0.072130404*Vds_cgs+-0.43343088*Lg_cgs+0.7703464);
hcgs1_22 = tanh(-1.1008723*Vgs_cgs+0.7357464*Vds_cgs+-0.35802382*Lg_cgs+0.35450834);
hcgs1_23 = tanh(-1.0641274*Vgs_cgs+-0.023895433*Vds_cgs+0.312323*Lg_cgs+0.58924264);
hcgs1_24 = tanh(1.1386739*Vgs_cgs+-0.5871172*Vds_cgs+-0.12789965*Lg_cgs+-0.42580304);
hcgs2_0 = tanh(-0.8456805*hcgs1_0+0.81710136*hcgs1_1+-0.22456154*hcgs1_2+-0.14914224*hcgs1_3+-2.0348866*hcgs1_4+-0.747218*hcgs1_5+-0.2158404*hcgs1_6+2.553406*hcgs1_7+0.42889893*hcgs1_8+-2.4390838*hcgs1_9+0.01141642*hcgs1_10+0.29778206*hcgs1_11+0.2695455*hcgs1_12+1.7889941*hcgs1_13+0.009541916*hcgs1_14+0.8799212*hcgs1_15+-1.8207581*hcgs1_16+-0.5563907*hcgs1_17+-2.550983*hcgs1_18+-0.24775197*hcgs1_19+0.3296183*hcgs1_20+0.25748515*hcgs1_21+0.8575212*hcgs1_22+0.19629534*hcgs1_23+-3.185923*hcgs1_24+0.30510485);
hcgs2_1 = tanh(0.5944262*hcgs1_0+0.047796533*hcgs1_1+-0.5502816*hcgs1_2+0.00890337*hcgs1_3+-0.68498886*hcgs1_4+-2.5434804*hcgs1_5+0.38445947*hcgs1_6+1.0074053*hcgs1_7+-0.22382292*hcgs1_8+-3.1384215*hcgs1_9+0.0029475465*hcgs1_10+0.30534053*hcgs1_11+0.4773358*hcgs1_12+2.1924813*hcgs1_13+0.014758705*hcgs1_14+0.32548565*hcgs1_15+-1.1178577*hcgs1_16+-1.3329682*hcgs1_17+-1.9556054*hcgs1_18+0.6174226*hcgs1_19+2.260632*hcgs1_20+0.18014935*hcgs1_21+1.1065633*hcgs1_22+0.87714285*hcgs1_23+-2.8133676*hcgs1_24+0.68831825);
hcgs2_2 = tanh(-0.16991197*hcgs1_0+1.8664104*hcgs1_1+-0.3474432*hcgs1_2+-0.21696573*hcgs1_3+-2.5008323*hcgs1_4+-0.2903099*hcgs1_5+1.6678329*hcgs1_6+-1.6792856*hcgs1_7+-1.7562099*hcgs1_8+-0.25893897*hcgs1_9+-0.04291705*hcgs1_10+-0.00012147065*hcgs1_11+0.026284702*hcgs1_12+-0.73358375*hcgs1_13+0.15483585*hcgs1_14+-1.0945101*hcgs1_15+-0.56847095*hcgs1_16+0.18457307*hcgs1_17+1.4761636*hcgs1_18+1.4470772*hcgs1_19+0.47771305*hcgs1_20+-0.1977162*hcgs1_21+-1.5351593*hcgs1_22+0.29518163*hcgs1_23+0.60733813*hcgs1_24+-0.10970557);
hcgs2_3 = tanh(0.23839453*hcgs1_0+-0.008309026*hcgs1_1+0.54371554*hcgs1_2+-0.10062454*hcgs1_3+0.27675664*hcgs1_4+1.0899066*hcgs1_5+-0.3777212*hcgs1_6+0.13016528*hcgs1_7+-0.012133315*hcgs1_8+1.1119828*hcgs1_9+-0.04014963*hcgs1_10+-0.4047089*hcgs1_11+-0.3015341*hcgs1_12+-1.6089342*hcgs1_13+-0.05156553*hcgs1_14+-0.92389685*hcgs1_15+0.120922476*hcgs1_16+1.1602905*hcgs1_17+-1.4947407*hcgs1_18+-0.18796265*hcgs1_19+-1.6901983*hcgs1_20+-0.035788976*hcgs1_21+-0.99925464*hcgs1_22+-0.67925924*hcgs1_23+1.6767167*hcgs1_24+-0.3653112);
hcgs2_4 = tanh(2.0752943*hcgs1_0+-0.3572386*hcgs1_1+-0.3549206*hcgs1_2+-0.29379958*hcgs1_3+-1.2869327*hcgs1_4+-0.4479244*hcgs1_5+0.031573102*hcgs1_6+1.4112504*hcgs1_7+0.5260651*hcgs1_8+-2.0343685*hcgs1_9+0.0187355*hcgs1_10+0.04147746*hcgs1_11+0.28817755*hcgs1_12+1.6051354*hcgs1_13+-0.008745322*hcgs1_14+1.0508798*hcgs1_15+-0.7435123*hcgs1_16+0.019853538*hcgs1_17+-1.1326213*hcgs1_18+-0.49617997*hcgs1_19+0.5881124*hcgs1_20+0.3453093*hcgs1_21+0.697278*hcgs1_22+0.34144053*hcgs1_23+-0.39954275*hcgs1_24+0.24203716);
hcgs2_5 = tanh(-0.8049178*hcgs1_0+0.9928581*hcgs1_1+0.3324538*hcgs1_2+-0.32453984*hcgs1_3+-1.2684071*hcgs1_4+0.5504112*hcgs1_5+-0.4549791*hcgs1_6+-1.4632839*hcgs1_7+0.37171695*hcgs1_8+0.72572297*hcgs1_9+-0.025831597*hcgs1_10+-0.21172419*hcgs1_11+-0.85458016*hcgs1_12+-0.8990451*hcgs1_13+-0.021322189*hcgs1_14+-1.4535208*hcgs1_15+-0.35931605*hcgs1_16+0.488443*hcgs1_17+0.0592027*hcgs1_18+-0.3993243*hcgs1_19+-0.7132404*hcgs1_20+-0.7187561*hcgs1_21+-0.021962876*hcgs1_22+-0.1357851*hcgs1_23+0.233105*hcgs1_24+-0.5199506);
hcgs2_6 = tanh(0.5850198*hcgs1_0+0.19749781*hcgs1_1+1.0971322*hcgs1_2+1.451523*hcgs1_3+-0.18752462*hcgs1_4+0.5928157*hcgs1_5+0.26702794*hcgs1_6+-1.1799154*hcgs1_7+0.42238823*hcgs1_8+0.34430432*hcgs1_9+0.36709026*hcgs1_10+0.76817995*hcgs1_11+1.4431945*hcgs1_12+0.28747907*hcgs1_13+0.1555853*hcgs1_14+1.4119282*hcgs1_15+-0.23534247*hcgs1_16+-0.043365728*hcgs1_17+-0.45434403*hcgs1_18+-0.6113481*hcgs1_19+-0.071436815*hcgs1_20+1.336255*hcgs1_21+0.048494633*hcgs1_22+-0.5316062*hcgs1_23+0.1436653*hcgs1_24+0.9528472);
hcgs2_7 = tanh(-0.37940532*hcgs1_0+-1.2876422*hcgs1_1+0.13731669*hcgs1_2+0.17509227*hcgs1_3+0.8986726*hcgs1_4+1.0229409*hcgs1_5+-0.69503534*hcgs1_6+0.20359293*hcgs1_7+0.80313087*hcgs1_8+1.0088204*hcgs1_9+-0.06411503*hcgs1_10+-0.23810008*hcgs1_11+-0.22483361*hcgs1_12+-0.7514442*hcgs1_13+-0.022351535*hcgs1_14+-0.029597659*hcgs1_15+-0.81831634*hcgs1_16+0.25210202*hcgs1_17+-1.454332*hcgs1_18+-0.59304476*hcgs1_19+-0.89324987*hcgs1_20+0.32196864*hcgs1_21+0.43833193*hcgs1_22+-0.8081428*hcgs1_23+0.38283762*hcgs1_24+-0.023465121);
hcgs2_8 = tanh(0.06450101*hcgs1_0+-0.32645157*hcgs1_1+0.33345243*hcgs1_2+0.12592125*hcgs1_3+0.9819371*hcgs1_4+1.568468*hcgs1_5+0.21460815*hcgs1_6+-1.0372665*hcgs1_7+-0.29271138*hcgs1_8+2.8030427*hcgs1_9+0.028697932*hcgs1_10+-0.57627803*hcgs1_11+-0.063452154*hcgs1_12+-1.590045*hcgs1_13+0.014249704*hcgs1_14+0.045245085*hcgs1_15+0.4989924*hcgs1_16+0.8713646*hcgs1_17+1.1842577*hcgs1_18+-0.008994069*hcgs1_19+-1.1241162*hcgs1_20+0.00919466*hcgs1_21+-1.1247435*hcgs1_22+-0.8297448*hcgs1_23+2.3253732*hcgs1_24+0.1950006);
hcgs2_9 = tanh(-0.45197833*hcgs1_0+0.045947105*hcgs1_1+-0.25987926*hcgs1_2+0.5171293*hcgs1_3+-0.1316219*hcgs1_4+0.067848496*hcgs1_5+0.8087117*hcgs1_6+-0.9547865*hcgs1_7+-0.5715785*hcgs1_8+0.32714853*hcgs1_9+0.036904156*hcgs1_10+0.13872579*hcgs1_11+0.12824427*hcgs1_12+0.11992727*hcgs1_13+0.07935975*hcgs1_14+-0.5361036*hcgs1_15+0.53884923*hcgs1_16+-0.039713964*hcgs1_17+0.7091841*hcgs1_18+0.48865792*hcgs1_19+0.18420732*hcgs1_20+0.07967269*hcgs1_21+-0.30234754*hcgs1_22+0.17830539*hcgs1_23+-0.11796092*hcgs1_24+-0.13467003);
hcgs2_10 = tanh(-1.6391398*hcgs1_0+-0.34285977*hcgs1_1+-0.3121803*hcgs1_2+0.41148263*hcgs1_3+-0.3336083*hcgs1_4+-1.5920037*hcgs1_5+-0.18015313*hcgs1_6+1.850319*hcgs1_7+0.17927983*hcgs1_8+-2.8341568*hcgs1_9+-0.030394657*hcgs1_10+0.69309235*hcgs1_11+0.2665585*hcgs1_12+2.2477663*hcgs1_13+-0.009332433*hcgs1_14+-0.3326121*hcgs1_15+-2.0456257*hcgs1_16+-0.9294434*hcgs1_17+-1.1023426*hcgs1_18+0.111194305*hcgs1_19+1.141862*hcgs1_20+0.71554065*hcgs1_21+1.1074047*hcgs1_22+0.88629806*hcgs1_23+-2.3181875*hcgs1_24+0.6508097);
hcgs2_11 = tanh(-0.24050619*hcgs1_0+-0.41003644*hcgs1_1+-1.2268633*hcgs1_2+-1.3124051*hcgs1_3+-0.1936789*hcgs1_4+-0.87841165*hcgs1_5+-0.020659437*hcgs1_6+-1.9815321*hcgs1_7+-0.087647766*hcgs1_8+-0.86529773*hcgs1_9+-0.1343042*hcgs1_10+-0.13795137*hcgs1_11+-1.2411678*hcgs1_12+-0.5560807*hcgs1_13+0.009826684*hcgs1_14+-1.6039407*hcgs1_15+-0.05220601*hcgs1_16+-0.25667432*hcgs1_17+-0.093644366*hcgs1_18+0.53593457*hcgs1_19+0.87013644*hcgs1_20+-1.2723198*hcgs1_21+0.009109739*hcgs1_22+1.0373011*hcgs1_23+-0.06875387*hcgs1_24+-0.96754915);
y_cgs = -0.16241902*hcgs2_0+-0.12451764*hcgs2_1+-0.04949069*hcgs2_2+0.082015745*hcgs2_3+-0.12691256*hcgs2_4+-0.18902193*hcgs2_5+-0.45962262*hcgs2_6+0.07102054*hcgs2_7+-0.59871113*hcgs2_8+0.095522754*hcgs2_9+-0.4854874*hcgs2_10+-0.4512705*hcgs2_11+0.3220441;

h1_0 = tanh(0.0067332466*Vgs+0.0014811404*Vds+-0.089835726*Lg+0.09066404);
h1_1 = tanh(0.11106648*Vgs+0.40663162*Vds+0.0077667693*Lg+-0.10081332);
h1_2 = tanh(1.5560061*Vgs+2.696172*Vds+-0.2839149*Lg+-0.3486124);
h1_3 = tanh(-2.0344324*Vgs+-0.28681883*Vds+0.8085338*Lg+0.0026162667);
h1_4 = tanh(-0.03341659*Vgs+-0.15408932*Vds+-0.015416802*Lg+0.04370213);
h1_5 = tanh(1.4746779*Vgs+0.33599785*Vds+-0.2669822*Lg+-0.42193142);
h1_6 = tanh(-0.16598122*Vgs+-2.3765175*Vds+0.11762294*Lg+0.019988127);
h1_7 = tanh(4.3143744*Vgs+-0.5703343*Vds+-0.3085829*Lg+-0.50043374);
h1_8 = tanh(-0.4936719*Vgs+36.42876*Vds+0.32744452*Lg+0.24776502);
h1_9 = tanh(0.4869826*Vgs+-0.13276859*Vds+0.28959593*Lg+-0.3828168);
h1_10 = tanh(0.000804813*Vgs+0.0004923456*Vds+-0.41243985*Lg+0.41356155);
h1_11 = tanh(2.6073072*Vgs+-0.56419706*Vds+-0.111921*Lg+-0.37480572);
h1_12 = tanh(0.0020444687*Vgs+0.0014842966*Vds+0.21013871*Lg+-0.20708004);
h1_13 = tanh(-2.6335895*Vgs+0.28439838*Vds+0.321686*Lg+0.41039804);
h1_14 = tanh(0.0034599572*Vgs+0.0084134*Vds+-0.034978658*Lg+0.037748303);
h1_15 = tanh(0.0025394042*Vgs+0.00083049946*Vds+-0.13070253*Lg+0.13411763);
h1_16 = tanh(-2.1379406*Vgs+-0.57477415*Vds+0.19879702*Lg+0.6043196);
h1_17 = tanh(-0.9647693*Vgs+3.0132833*Vds+0.13054319*Lg+0.38879853);
h1_18 = tanh(-1.6564686*Vgs+-0.06445829*Vds+0.39810786*Lg+0.21570432);
h1_19 = tanh(-0.120745726*Vgs+-0.37977916*Vds+-0.20842548*Lg+0.33059505);
h1_20 = tanh(-0.5346294*Vgs+-0.24575421*Vds+0.42274392*Lg+-0.095065445);
h1_21 = tanh(-0.17100386*Vgs+-0.36405364*Vds+-0.32086778*Lg+-0.45500055);
h1_22 = tanh(-0.3456514*Vgs+-0.43013823*Vds+-0.14385213*Lg+0.4731826);
h1_23 = tanh(0.28758252*Vgs+-0.55982685*Vds+0.44342747*Lg+-0.34977767);
h1_24 = tanh(0.08224837*Vgs+0.35958192*Vds+0.059084654*Lg+-0.1397865);

h2_0 = tanh(-0.8091375*h1_0+-0.43552017*h1_1+-0.8155236*h1_2+0.24130166*h1_3+0.14224924*h1_4+-0.62978196*h1_5+0.6101532*h1_6+-0.43199107*h1_7+-2.3122218*h1_8+-0.23163876*h1_9+0.068008065*h1_10+-0.03888623*h1_11+-0.014134661*h1_12+-0.06591678*h1_13+0.022440521*h1_14+-0.27041718*h1_15+0.090823404*h1_16+-0.26772383*h1_17+0.47534344*h1_18+0.73750144*h1_19+0.50188285*h1_20+0.3184862*h1_21+0.3608627*h1_22+0.79056877*h1_23+-0.037502155*h1_24+-0.24878933);
h2_1 = tanh(-0.03261362*h1_0+-0.06024928*h1_1+-0.10186445*h1_2+0.018033225*h1_3+0.51713187*h1_4+0.022300791*h1_5+0.015979188*h1_6+0.056999434*h1_7+0.035186633*h1_8+0.25107002*h1_9+-0.012781056*h1_10+-0.3380685*h1_11+0.05043952*h1_12+-0.24957459*h1_13+0.024472937*h1_14+-0.08896992*h1_15+0.053890992*h1_16+-0.0101861*h1_17+-0.031921674*h1_18+0.17910303*h1_19+-0.03255347*h1_20+-0.38824677*h1_21+-0.14763784*h1_22+-0.24868536*h1_23+-0.024086645*h1_24+-0.18488966);
h2_2 = tanh(0.12152682*h1_0+0.009792632*h1_1+-0.29032546*h1_2+0.5965219*h1_3+-0.021902572*h1_4+-0.5883061*h1_5+0.17799598*h1_6+-0.92929643*h1_7+0.32916892*h1_8+-0.2568552*h1_9+-0.067421295*h1_10+-1.1449344*h1_11+0.007887112*h1_12+0.276745*h1_13+-0.033592574*h1_14+0.1040227*h1_15+0.23562248*h1_16+-0.18375605*h1_17+1.0453725*h1_18+0.33611628*h1_19+0.6393779*h1_20+0.06726488*h1_21+0.7879763*h1_22+-0.14922209*h1_23+-0.18613423*h1_24+0.28223407);
h2_3 = tanh(-0.18859175*h1_0+-0.9337733*h1_1+-0.938285*h1_2+0.7002026*h1_3+0.6061784*h1_4+-0.52529997*h1_5+0.71481675*h1_6+-0.38263503*h1_7+-0.5072332*h1_8+0.1263292*h1_9+0.04664359*h1_10+-0.5296314*h1_11+-0.033964746*h1_12+0.6460025*h1_13+-0.0231704*h1_14+-0.38591123*h1_15+0.0872077*h1_16+-0.5042024*h1_17+0.47931066*h1_18+0.50751704*h1_19+-0.063635096*h1_20+0.018421784*h1_21+0.08422998*h1_22+0.30641475*h1_23+-0.524482*h1_24+-0.26979908);
h2_4 = tanh(-0.034289524*h1_0+-0.11348127*h1_1+0.48059276*h1_2+-1.123194*h1_3+0.12442129*h1_4+0.49476302*h1_5+0.0863118*h1_6+0.47754285*h1_7+0.2202004*h1_8+0.41435316*h1_9+0.028558401*h1_10+0.36081842*h1_11+-0.008486773*h1_12+-0.9903806*h1_13+0.015499473*h1_14+-0.063613005*h1_15+-1.4330287*h1_16+-0.74456465*h1_17+-0.5569409*h1_18+-0.019323817*h1_19+-0.14176102*h1_20+0.49098673*h1_21+-0.057230044*h1_22+0.515492*h1_23+-0.13265039*h1_24+-0.18507467);
h2_5 = tanh(-0.09933434*h1_0+-0.15035452*h1_1+-0.5133741*h1_2+-0.47027865*h1_3+0.21104498*h1_4+0.14945817*h1_5+0.10640489*h1_6+0.1787739*h1_7+0.060723394*h1_8+-0.5602644*h1_9+-0.0019350805*h1_10+0.5330786*h1_11+0.012645531*h1_12+-0.42403966*h1_13+0.018393166*h1_14+-0.00062784646*h1_15+-0.0052586636*h1_16+1.0866524*h1_17+0.078084014*h1_18+0.059300236*h1_19+0.32314536*h1_20+0.49137965*h1_21+0.09876712*h1_22+-0.583638*h1_23+-0.1759503*h1_24+-0.18313222);
h2_6 = tanh(-0.1285073*h1_0+-1.032602*h1_1+-1.224141*h1_2+0.14631094*h1_3+0.65741867*h1_4+-0.22908972*h1_5+0.63241625*h1_6+-0.88521755*h1_7+0.09097795*h1_8+0.09149886*h1_9+0.027507082*h1_10+-0.63233715*h1_11+-0.02061426*h1_12+0.1104531*h1_13+-0.012734477*h1_14+-0.34623924*h1_15+-0.18294835*h1_16+-0.045275174*h1_17+0.35704163*h1_18+0.5909152*h1_19+0.073851526*h1_20+0.49004716*h1_21+0.19812724*h1_22+0.3784807*h1_23+-0.6437184*h1_24+-0.3594689);
h2_7 = tanh(0.119550616*h1_0+-0.035170615*h1_1+-0.60996103*h1_2+0.40164798*h1_3+-0.007347775*h1_4+-0.30736676*h1_5+-0.13570982*h1_6+0.9896757*h1_7+-4.0502048*h1_8+0.053264104*h1_9+-0.012164457*h1_10+0.48190302*h1_11+0.014136277*h1_12+-0.5162279*h1_13+0.014227704*h1_14+0.05181294*h1_15+0.7717682*h1_16+-0.111988194*h1_17+0.062060844*h1_18+-0.044897318*h1_19+-0.15565042*h1_20+0.24919312*h1_21+-0.07993477*h1_22+-0.09538691*h1_23+-0.0052977665*h1_24+-0.10968423);
h2_8 = tanh(0.079706475*h1_0+-0.5814533*h1_1+0.6996235*h1_2+-0.16522586*h1_3+0.630409*h1_4+0.29656532*h1_5+-0.5331364*h1_6+0.114606544*h1_7+-0.21106683*h1_8+0.0467022*h1_9+-0.06535354*h1_10+-0.24001631*h1_11+0.059368264*h1_12+0.15451497*h1_13+0.053622272*h1_14+0.12981157*h1_15+0.5445277*h1_16+0.24295534*h1_17+-0.26532695*h1_18+0.56733835*h1_19+0.12550347*h1_20+0.048389148*h1_21+0.5622483*h1_22+0.6891362*h1_23+-0.76375955*h1_24+-0.2676767);
h2_9 = tanh(-0.03992191*h1_0+0.09928779*h1_1+1.0056654*h1_2+-2.3181243*h1_3+-0.0916434*h1_4+2.143644*h1_5+0.19818373*h1_6+2.8020356*h1_7+-0.47644797*h1_8+0.24747562*h1_9+0.02024143*h1_10+1.3736787*h1_11+0.006931587*h1_12+-3.888161*h1_13+0.018778825*h1_14+-0.0041158814*h1_15+-1.5533967*h1_16+-0.71390355*h1_17+-2.8108795*h1_18+-0.24579133*h1_19+-1.128639*h1_20+0.2231992*h1_21+-1.2298777*h1_22+0.043120787*h1_23+0.403965*h1_24+-0.17281148);
h2_10 = tanh(0.35093632*h1_0+-0.05374117*h1_1+0.16745348*h1_2+-0.19781992*h1_3+-0.07950959*h1_4+0.29579905*h1_5+-0.5073861*h1_6+-0.14164843*h1_7+0.70651436*h1_8+0.29345548*h1_9+-0.054172043*h1_10+-0.28257352*h1_11+0.033599235*h1_12+0.017732412*h1_13+0.02154612*h1_14+0.1586723*h1_15+-0.23733242*h1_16+0.43727452*h1_17+-0.084653825*h1_18+-0.054423757*h1_19+-0.36601782*h1_20+-0.07235579*h1_21+-0.03668117*h1_22+-0.05778476*h1_23+-0.020711297*h1_24+0.24233255);
h2_11 = tanh(0.009613743*h1_0+-0.26873523*h1_1+-0.0937895*h1_2+-0.17233954*h1_3+0.2600588*h1_4+-0.41362444*h1_5+-0.13627699*h1_6+-0.03051018*h1_7+0.028052136*h1_8+0.06536644*h1_9+-0.029295161*h1_10+-0.017168272*h1_11+0.016685432*h1_12+-0.15576635*h1_13+0.08295777*h1_14+-0.16339928*h1_15+-0.069266655*h1_16+-0.07842072*h1_17+0.22933975*h1_18+-0.07057512*h1_19+0.172754*h1_20+-0.21173981*h1_21+-0.8436922*h1_22+0.28658*h1_23+-0.018899215*h1_24+-0.11145156);
y = 0.13345447*h2_0+0.0023934222*h2_1+0.1793076*h2_2+0.51211137*h2_3+0.2699503*h2_4+0.11368197*h2_5+-0.5013421*h2_6+-0.61606425*h2_7+-0.037382632*h2_8+0.18645377*h2_9+0.32913932*h2_10+-0.00013747951*h2_11+-0.1796401;

Cgd = pow(10, (y_cgd/normO_cgd + MinO_cgd))*W/15; //traning width was 15um
Cgs = pow(10, (y_cgs/normO_cgs + MinO_cgs))*W/15;
Cgg = Cgd+Cgs;

Id = pow(10, (y/normI + MinI))*W*3;
I(g, d) <+ Cgd*ddt(Vg-Vd) ;
I(g, s) <+ Cgs*ddt(Vg-Vs) ;

if (Vd >= Vs) begin
	I(d, s) <+ dir*Id;
end

else begin
	I(d, s) <+ dir*Id;
end

end
endmodule
